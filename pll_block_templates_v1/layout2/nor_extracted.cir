* Extracted by KLayout with GF180MCU LVS runset on : 14/07/2026 08:25

* cell nor
* pin SUB
.SUBCKT nor SUB
* device instance $1 r0 *1 8.02,9.19 pfet_03v3
M$1 \$5 \$3 \$16 \$13 pfet_03v3 L=0.28U W=2.1U AS=1.365P AD=1.365P PS=5.5U
+ PD=5.5U
* device instance $2 r0 *1 3.37,9.22 pfet_03v3
M$2 \$16 \$10 \$13 \$13 pfet_03v3 L=0.28U W=2.1U AS=1.365P AD=1.365P PS=5.5U
+ PD=5.5U
* device instance $3 r0 *1 8.02,4.59 nfet_03v3
M$3 \$5 \$3 SUB SUB nfet_03v3 L=0.28U W=0.3U AS=0.2418P AD=0.2418P PS=2.1U
+ PD=2.1U
* device instance $4 r0 *1 3.37,4.63 nfet_03v3
M$4 \$5 \$10 SUB SUB nfet_03v3 L=0.28U W=0.3U AS=0.2418P AD=0.2418P PS=2.1U
+ PD=2.1U
.ENDS nor
