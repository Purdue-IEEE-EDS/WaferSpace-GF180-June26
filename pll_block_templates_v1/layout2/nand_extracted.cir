* Extracted by KLayout with GF180MCU LVS runset on : 14/07/2026 07:17

* cell nand
* pin SUB
.SUBCKT nand SUB
* device instance $1 r0 *1 6.41,2.995 pfet_03v3
M$1 \$6 \$4 \$14 \$14 pfet_03v3 L=0.28U W=0.3U AS=0.2594P AD=0.2594P PS=2.18U
+ PD=2.18U
* device instance $2 r0 *1 0.81,2.97 pfet_03v3
M$2 \$6 \$10 \$14 \$14 pfet_03v3 L=0.28U W=0.3U AS=0.2594P AD=0.2594P PS=2.18U
+ PD=2.18U
* device instance $3 r0 *1 3.425,-0.505 nfet_03v3
M$3 \$6 \$10 \$1 SUB nfet_03v3 L=0.28U W=0.3U AS=0.2418P AD=0.2418P PS=2.1U
+ PD=2.1U
* device instance $4 r0 *1 3.425,-2.43 nfet_03v3
M$4 \$1 \$4 SUB SUB nfet_03v3 L=0.28U W=0.3U AS=0.2418P AD=0.2418P PS=2.1U
+ PD=2.1U
.ENDS nand
