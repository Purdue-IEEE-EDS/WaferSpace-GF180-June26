* NGSPICE file created from tm_to_bin2.ext - technology: gf180mcuD

.subckt pfet a_734_0# a_28_n136# a_254_0# a_188_n136# a_348_n136# a_414_0# a_n92_0#
+ a_94_0# a_574_0# a_508_n136# a_668_n136# w_n230_n138# VSUBS
X0 a_734_0# a_668_n136# a_574_0# w_n230_n138# pfet_03v3 ad=2.145p pd=7.9u as=0.858p ps=3.82u w=3.3u l=0.28u
X1 a_254_0# a_188_n136# a_94_0# w_n230_n138# pfet_03v3 ad=0.858p pd=3.82u as=0.858p ps=3.82u w=3.3u l=0.28u
X2 a_574_0# a_508_n136# a_414_0# w_n230_n138# pfet_03v3 ad=0.858p pd=3.82u as=0.858p ps=3.82u w=3.3u l=0.28u
X3 a_94_0# a_28_n136# a_n92_0# w_n230_n138# pfet_03v3 ad=0.858p pd=3.82u as=2.145p ps=7.9u w=3.3u l=0.28u
X4 a_414_0# a_348_n136# a_254_0# w_n230_n138# pfet_03v3 ad=0.858p pd=3.82u as=0.858p ps=3.82u w=3.3u l=0.28u
C0 a_668_n136# a_508_n136# 0.06717f
C1 a_348_n136# w_n230_n138# 0.10304f
C2 a_94_0# a_254_0# 0.32736f
C3 a_188_n136# a_254_0# 0.02517f
C4 a_348_n136# a_188_n136# 0.06717f
C5 a_668_n136# a_574_0# 0.02517f
C6 a_574_0# a_734_0# 0.23758f
C7 a_508_n136# w_n230_n138# 0.10304f
C8 a_348_n136# a_254_0# 0.02517f
C9 a_668_n136# a_734_0# 0.02318f
C10 a_n92_0# a_28_n136# 0.02318f
C11 w_n230_n138# a_28_n136# 0.12042f
C12 a_254_0# a_414_0# 0.32736f
C13 a_28_n136# a_94_0# 0.02517f
C14 a_348_n136# a_414_0# 0.02517f
C15 a_28_n136# a_188_n136# 0.06717f
C16 a_348_n136# a_508_n136# 0.06717f
C17 a_668_n136# w_n230_n138# 0.12611f
C18 w_n230_n138# a_734_0# 0.4196f
C19 a_508_n136# a_414_0# 0.02517f
C20 a_n92_0# w_n230_n138# 0.03499f
C21 a_n92_0# a_94_0# 0.23758f
C22 a_414_0# a_574_0# 0.32736f
C23 w_n230_n138# a_188_n136# 0.10304f
C24 a_508_n136# a_574_0# 0.02517f
C25 a_188_n136# a_94_0# 0.02517f
C26 a_734_0# VSUBS 0.02093f
C27 a_574_0# VSUBS 0.02093f
C28 a_414_0# VSUBS 0.02093f
C29 a_254_0# VSUBS 0.02093f
C30 a_94_0# VSUBS 0.02093f
C31 a_n92_0# VSUBS 0.10673f
C32 a_668_n136# VSUBS 0.0592f
C33 a_508_n136# VSUBS 0.04564f
C34 a_348_n136# VSUBS 0.04564f
C35 a_188_n136# VSUBS 0.04564f
C36 a_28_n136# VSUBS 0.06489f
C37 w_n230_n138# VSUBS 3.95749f
.ends

.subckt nfet a_350_568# a_254_0# a_414_0# a_510_568# a_190_568# a_n84_0# a_30_568#
+ a_94_0# a_574_0# a_696_0#
X0 a_254_0# a_190_568# a_94_0# a_696_0# nfet_03v3 ad=0.6604p pd=3.06u as=0.6604p ps=3.06u w=2.54u l=0.28u
X1 a_574_0# a_510_568# a_414_0# a_696_0# nfet_03v3 ad=1.5494p pd=6.3u as=0.6604p ps=3.06u w=2.54u l=0.28u
X2 a_94_0# a_30_568# a_n84_0# a_696_0# nfet_03v3 ad=0.6604p pd=3.06u as=1.5494p ps=6.3u w=2.54u l=0.28u
X3 a_414_0# a_350_568# a_254_0# a_696_0# nfet_03v3 ad=0.6604p pd=3.06u as=0.6604p ps=3.06u w=2.54u l=0.28u
C0 a_190_568# a_350_568# 0.0661f
C1 a_254_0# a_190_568# 0.01674f
C2 a_n84_0# a_94_0# 0.16004f
C3 a_254_0# a_350_568# 0.01674f
C4 a_574_0# a_510_568# 0.01563f
C5 a_30_568# a_n84_0# 0.01563f
C6 a_350_568# a_510_568# 0.0661f
C7 a_414_0# a_574_0# 0.16004f
C8 a_30_568# a_94_0# 0.01674f
C9 a_414_0# a_350_568# 0.01674f
C10 a_254_0# a_414_0# 0.2134f
C11 a_190_568# a_94_0# 0.01674f
C12 a_414_0# a_510_568# 0.01674f
C13 a_30_568# a_190_568# 0.0661f
C14 a_254_0# a_94_0# 0.2134f
C15 a_574_0# a_696_0# 0.31292f
C16 a_414_0# a_696_0# 0.02648f
C17 a_254_0# a_696_0# 0.02648f
C18 a_94_0# a_696_0# 0.02648f
C19 a_n84_0# a_696_0# 0.10124f
C20 a_510_568# a_696_0# 0.18161f
C21 a_350_568# a_696_0# 0.14578f
C22 a_190_568# a_696_0# 0.14578f
C23 a_30_568# a_696_0# 0.18161f
.ends

.subckt NAND3 OUT VDD a_n2143_982# a_2506_982# a_994_982# a_n3730_982# m1_n3706_n1374#
+ m1_n2243_n1314# GND
Xpfet_0 VDD a_994_982# a_n593_982# a_994_982# a_994_982# VDD a_n593_982# VDD a_n593_982#
+ a_994_982# a_994_982# VDD GND pfet
Xpfet_1 VDD a_n2143_982# a_2506_982# a_n2143_982# a_n2143_982# VDD a_2506_982# VDD
+ a_2506_982# a_n2143_982# a_n2143_982# VDD GND pfet
Xpfet_2 VDD a_n3730_982# a_2506_982# a_n3730_982# a_n3730_982# VDD a_2506_982# VDD
+ a_2506_982# a_n3730_982# a_n3730_982# VDD GND pfet
Xpfet_3 VDD a_2506_982# OUT a_2506_982# a_2506_982# VDD OUT VDD OUT a_2506_982# a_2506_982#
+ VDD GND pfet
Xpfet_4 VDD a_n593_982# a_2506_982# a_n593_982# a_n593_982# VDD a_2506_982# VDD a_2506_982#
+ a_n593_982# a_n593_982# VDD GND pfet
Xnfet_0 a_n2143_982# m1_n2243_n1314# m1_n3706_n1374# a_n2143_982# a_n2143_982# m1_n2243_n1314#
+ a_n2143_982# m1_n3706_n1374# m1_n2243_n1314# GND nfet
Xnfet_1 a_994_982# GND a_n593_982# a_994_982# a_994_982# GND a_994_982# a_n593_982#
+ GND GND nfet
Xnfet_2 a_n593_982# GND m1_n2243_n1314# a_n593_982# a_n593_982# GND a_n593_982# m1_n2243_n1314#
+ GND GND nfet
Xnfet_3 a_n3730_982# m1_n3706_n1374# a_2506_982# a_n3730_982# a_n3730_982# m1_n3706_n1374#
+ a_n3730_982# a_2506_982# m1_n3706_n1374# GND nfet
Xnfet_4 a_2506_982# GND OUT a_2506_982# a_2506_982# GND a_2506_982# OUT GND GND nfet
C0 OUT a_2506_982# 0.912f
C1 VDD OUT 0.31548f
C2 a_994_982# a_2506_982# 0.30956f
C3 a_n2143_982# a_2506_982# 0.67769f
C4 a_n3730_982# a_2506_982# 0.76907f
C5 VDD a_994_982# 0.27728f
C6 a_n593_982# a_2506_982# 0.99768f
C7 VDD a_n2143_982# 0.28679f
C8 VDD a_n3730_982# 0.28464f
C9 VDD a_n593_982# 0.55922f
C10 VDD a_2506_982# 1.23794f
C11 a_994_982# m1_n3706_n1374# 0.21268f
C12 m1_n2243_n1314# m1_n3706_n1374# 0.18462f
C13 a_n2143_982# m1_n3706_n1374# 0.25682f
C14 a_n3730_982# m1_n3706_n1374# 0.10806f
C15 OUT a_n593_982# 0.05101f
C16 a_994_982# m1_n2243_n1314# 0.20937f
C17 a_n2143_982# a_994_982# 0.36792f
C18 a_n2143_982# m1_n2243_n1314# 0.09824f
C19 a_n3730_982# a_994_982# 0.08729f
C20 a_n3730_982# a_n2143_982# 0.15093f
C21 a_n593_982# a_994_982# 1.2113f
C22 a_n593_982# m1_n2243_n1314# 0.27291f
C23 a_n593_982# a_n2143_982# 0.05055f
C24 a_2506_982# m1_n3706_n1374# 0.11831f
C25 a_994_982# GND 1.63201f
C26 a_n2143_982# GND 1.0529f
C27 a_n3730_982# GND 0.81311f
C28 a_n593_982# GND 1.55572f
C29 OUT GND 0.92875f
C30 m1_n3706_n1374# GND 1.32186f
C31 a_2506_982# GND 2.2465f
C32 m1_n2243_n1314# GND 1.27576f
C33 VDD GND 5.15621f
.ends

.subckt tm_to_bin2 VDD comp[0] comp[1] comp[2] comp[3] comp[4] comp[5] comp[6] comp[7] comp[8] comp[9] comp[10] comp[11] comp[12] comp[13] comp[14] comp[15] comp[16] comp[17] comp[18] comp[19] comp[20] comp[21] comp[22] comp[23] comp[24] comp[25] comp[26] comp[27] comp[28] comp[29] comp[30] comp[31] comp[32] comp[33] comp[34] comp[35] comp[36] comp[37] comp[38] comp[39] comp[40] comp[41] comp[42] comp[43] comp[44] comp[45] comp[46] comp[47] comp[48] comp[49] comp[50] comp[51] comp[52] comp[53] comp[54] comp[55] comp[56] comp[57] comp[58] comp[59] comp[60] comp[61] comp[62] GND wl[62] wl[61] wl[60] wl[59] wl[58] wl[57] wl[56] wl[55] wl[54] wl[53] wl[52] wl[51] wl[50] wl[49] wl[48] wl[47] wl[46] wl[45] wl[44] wl[43] wl[42] wl[41] wl[40] wl[39] wl[38] wl[37] wl[36] wl[35] wl[34] wl[33] wl[32] wl[31] wl[30] wl[29] wl[28] wl[27] wl[26] wl[25] wl[24] wl[23] wl[22] wl[21] wl[20] wl[19] wl[18] wl[17] wl[16] wl[15] wl[14] wl[13] wl[12] wl[11] wl[10] wl[9] wl[8] wl[7] wl[6] wl[5] wl[4] wl[3] wl[2] wl[1] wl[0]

XNAND3_60 wl[2] VDD comp[2] NAND3_60/a_2506_982# comp[3] comp[1] NAND3_60/m1_n3706_n1374#
+ NAND3_60/m1_n2243_n1314# GND NAND3
XNAND3_50 wl[12] VDD comp[12] NAND3_50/a_2506_982# comp[13] comp[11] NAND3_50/m1_n3706_n1374#
+ NAND3_50/m1_n2243_n1314# GND NAND3
XNAND3_61 wl[1] VDD comp[1] NAND3_61/a_2506_982# comp[2] m1_n4168_2156# NAND3_61/m1_n3706_n1374#
+ NAND3_61/m1_n2243_n1314# GND NAND3
XNAND3_40 wl[22] VDD comp[22] NAND3_40/a_2506_982# comp[23] comp[21] NAND3_40/m1_n3706_n1374#
+ NAND3_40/m1_n2243_n1314# GND NAND3
XNAND3_51 wl[11] VDD comp[11] NAND3_51/a_2506_982# comp[12] comp[10] NAND3_51/m1_n3706_n1374#
+ NAND3_51/m1_n2243_n1314# GND NAND3
XNAND3_62 wl[0] VDD m1_n4168_2156# NAND3_62/a_2506_982# comp[1] VDD NAND3_62/m1_n3706_n1374#
+ NAND3_62/m1_n2243_n1314# GND NAND3
XNAND3_30 wl[32] VDD comp[32] NAND3_30/a_2506_982# comp[33] comp[31] NAND3_30/m1_n3706_n1374#
+ NAND3_30/m1_n2243_n1314# GND NAND3
XNAND3_41 wl[21] VDD comp[21] NAND3_41/a_2506_982# comp[22] comp[20] NAND3_41/m1_n3706_n1374#
+ NAND3_41/m1_n2243_n1314# GND NAND3
XNAND3_52 wl[10] VDD comp[10] NAND3_52/a_2506_982# comp[11] comp[9] NAND3_52/m1_n3706_n1374#
+ NAND3_52/m1_n2243_n1314# GND NAND3
XNAND3_20 wl[42] VDD comp[42] NAND3_20/a_2506_982# comp[43] comp[41] NAND3_20/m1_n3706_n1374#
+ NAND3_20/m1_n2243_n1314# GND NAND3
XNAND3_31 wl[31] VDD comp[31] NAND3_31/a_2506_982# comp[32] comp[30] NAND3_31/m1_n3706_n1374#
+ NAND3_31/m1_n2243_n1314# GND NAND3
XNAND3_42 wl[20] VDD comp[20] NAND3_42/a_2506_982# comp[21] comp[19] NAND3_42/m1_n3706_n1374#
+ NAND3_42/m1_n2243_n1314# GND NAND3
XNAND3_53 wl[9] VDD comp[9] NAND3_53/a_2506_982# comp[10] comp[8] NAND3_53/m1_n3706_n1374#
+ NAND3_53/m1_n2243_n1314# GND NAND3
XNAND3_0 wl[62] VDD comp[62] NAND3_0/a_2506_982# GND comp[61] NAND3_0/m1_n3706_n1374#
+ NAND3_0/m1_n2243_n1314# GND NAND3
XNAND3_10 wl[52] VDD comp[52] NAND3_10/a_2506_982# comp[53] comp[51] NAND3_10/m1_n3706_n1374#
+ NAND3_10/m1_n2243_n1314# GND NAND3
XNAND3_21 wl[41] VDD comp[41] NAND3_21/a_2506_982# comp[42] comp[40] NAND3_21/m1_n3706_n1374#
+ NAND3_21/m1_n2243_n1314# GND NAND3
XNAND3_32 wl[30] VDD comp[30] NAND3_32/a_2506_982# comp[31] comp[29] NAND3_32/m1_n3706_n1374#
+ NAND3_32/m1_n2243_n1314# GND NAND3
XNAND3_43 wl[19] VDD comp[19] NAND3_43/a_2506_982# comp[20] comp[18] NAND3_43/m1_n3706_n1374#
+ NAND3_43/m1_n2243_n1314# GND NAND3
XNAND3_54 wl[8] VDD comp[8] NAND3_54/a_2506_982# comp[9] comp[7] NAND3_54/m1_n3706_n1374#
+ NAND3_54/m1_n2243_n1314# GND NAND3
XNAND3_1 wl[61] VDD comp[61] NAND3_1/a_2506_982# comp[62] comp[60] NAND3_1/m1_n3706_n1374#
+ NAND3_1/m1_n2243_n1314# GND NAND3
XNAND3_11 wl[51] VDD comp[51] NAND3_11/a_2506_982# comp[52] comp[50] NAND3_11/m1_n3706_n1374#
+ NAND3_11/m1_n2243_n1314# GND NAND3
XNAND3_22 wl[40] VDD comp[40] NAND3_22/a_2506_982# comp[41] comp[39] NAND3_22/m1_n3706_n1374#
+ NAND3_22/m1_n2243_n1314# GND NAND3
XNAND3_33 wl[29] VDD comp[29] NAND3_33/a_2506_982# comp[30] comp[28] NAND3_33/m1_n3706_n1374#
+ NAND3_33/m1_n2243_n1314# GND NAND3
XNAND3_44 wl[18] VDD comp[18] NAND3_44/a_2506_982# comp[19] comp[17] NAND3_44/m1_n3706_n1374#
+ NAND3_44/m1_n2243_n1314# GND NAND3
XNAND3_55 wl[7] VDD comp[7] NAND3_55/a_2506_982# comp[8] comp[6] NAND3_55/m1_n3706_n1374#
+ NAND3_55/m1_n2243_n1314# GND NAND3
XNAND3_2 wl[60] VDD comp[60] NAND3_2/a_2506_982# comp[61] comp[59] NAND3_2/m1_n3706_n1374#
+ NAND3_2/m1_n2243_n1314# GND NAND3
XNAND3_12 wl[50] VDD comp[50] NAND3_12/a_2506_982# comp[51] comp[49] NAND3_12/m1_n3706_n1374#
+ NAND3_12/m1_n2243_n1314# GND NAND3
XNAND3_23 wl[39] VDD comp[39] NAND3_23/a_2506_982# comp[40] comp[38] NAND3_23/m1_n3706_n1374#
+ NAND3_23/m1_n2243_n1314# GND NAND3
XNAND3_34 wl[28] VDD comp[28] NAND3_34/a_2506_982# comp[29] comp[27] NAND3_34/m1_n3706_n1374#
+ NAND3_34/m1_n2243_n1314# GND NAND3
XNAND3_45 wl[17] VDD comp[17] NAND3_45/a_2506_982# comp[18] comp[16] NAND3_45/m1_n3706_n1374#
+ NAND3_45/m1_n2243_n1314# GND NAND3
XNAND3_56 wl[6] VDD comp[6] NAND3_56/a_2506_982# comp[7] comp[5] NAND3_56/m1_n3706_n1374#
+ NAND3_56/m1_n2243_n1314# GND NAND3
XNAND3_3 wl[59] VDD comp[59] NAND3_3/a_2506_982# comp[60] comp[58] NAND3_3/m1_n3706_n1374#
+ NAND3_3/m1_n2243_n1314# GND NAND3
XNAND3_13 wl[49] VDD comp[49] NAND3_13/a_2506_982# comp[50] comp[48] NAND3_13/m1_n3706_n1374#
+ NAND3_13/m1_n2243_n1314# GND NAND3
XNAND3_14 wl[48] VDD comp[48] NAND3_14/a_2506_982# comp[49] comp[47] NAND3_14/m1_n3706_n1374#
+ NAND3_14/m1_n2243_n1314# GND NAND3
XNAND3_24 wl[38] VDD comp[38] NAND3_24/a_2506_982# comp[39] comp[37] NAND3_24/m1_n3706_n1374#
+ NAND3_24/m1_n2243_n1314# GND NAND3
XNAND3_25 wl[37] VDD comp[37] NAND3_25/a_2506_982# comp[38] comp[36] NAND3_25/m1_n3706_n1374#
+ NAND3_25/m1_n2243_n1314# GND NAND3
XNAND3_35 wl[27] VDD comp[27] NAND3_35/a_2506_982# comp[28] comp[26] NAND3_35/m1_n3706_n1374#
+ NAND3_35/m1_n2243_n1314# GND NAND3
XNAND3_36 wl[26] VDD comp[26] NAND3_36/a_2506_982# comp[27] comp[25] NAND3_36/m1_n3706_n1374#
+ NAND3_36/m1_n2243_n1314# GND NAND3
XNAND3_46 wl[16] VDD comp[16] NAND3_46/a_2506_982# comp[17] comp[15] NAND3_46/m1_n3706_n1374#
+ NAND3_46/m1_n2243_n1314# GND NAND3
XNAND3_47 wl[15] VDD comp[15] NAND3_47/a_2506_982# comp[16] comp[14] NAND3_47/m1_n3706_n1374#
+ NAND3_47/m1_n2243_n1314# GND NAND3
XNAND3_57 wl[5] VDD comp[5] NAND3_57/a_2506_982# comp[6] comp[4] NAND3_57/m1_n3706_n1374#
+ NAND3_57/m1_n2243_n1314# GND NAND3
XNAND3_58 wl[4] VDD comp[4] NAND3_58/a_2506_982# comp[5] comp[3] NAND3_58/m1_n3706_n1374#
+ NAND3_58/m1_n2243_n1314# GND NAND3
XNAND3_4 wl[58] VDD comp[58] NAND3_4/a_2506_982# comp[59] comp[57] NAND3_4/m1_n3706_n1374#
+ NAND3_4/m1_n2243_n1314# GND NAND3
XNAND3_15 wl[47] VDD comp[47] NAND3_15/a_2506_982# comp[48] comp[46] NAND3_15/m1_n3706_n1374#
+ NAND3_15/m1_n2243_n1314# GND NAND3
XNAND3_26 wl[36] VDD comp[36] NAND3_26/a_2506_982# comp[37] comp[35] NAND3_26/m1_n3706_n1374#
+ NAND3_26/m1_n2243_n1314# GND NAND3
XNAND3_37 wl[25] VDD comp[25] NAND3_37/a_2506_982# comp[26] comp[24] NAND3_37/m1_n3706_n1374#
+ NAND3_37/m1_n2243_n1314# GND NAND3
XNAND3_48 wl[14] VDD comp[14] NAND3_48/a_2506_982# comp[15] comp[13] NAND3_48/m1_n3706_n1374#
+ NAND3_48/m1_n2243_n1314# GND NAND3
XNAND3_59 wl[3] VDD comp[3] NAND3_59/a_2506_982# comp[4] comp[2] NAND3_59/m1_n3706_n1374#
+ NAND3_59/m1_n2243_n1314# GND NAND3
XNAND3_5 wl[57] VDD comp[57] NAND3_5/a_2506_982# comp[58] comp[56] NAND3_5/m1_n3706_n1374#
+ NAND3_5/m1_n2243_n1314# GND NAND3
XNAND3_6 wl[56] VDD comp[56] NAND3_6/a_2506_982# comp[57] comp[55] NAND3_6/m1_n3706_n1374#
+ NAND3_6/m1_n2243_n1314# GND NAND3
XNAND3_16 wl[46] VDD comp[46] NAND3_16/a_2506_982# comp[47] comp[45] NAND3_16/m1_n3706_n1374#
+ NAND3_16/m1_n2243_n1314# GND NAND3
XNAND3_27 wl[35] VDD comp[35] NAND3_27/a_2506_982# comp[36] comp[34] NAND3_27/m1_n3706_n1374#
+ NAND3_27/m1_n2243_n1314# GND NAND3
XNAND3_38 wl[24] VDD comp[24] NAND3_38/a_2506_982# comp[25] comp[23] NAND3_38/m1_n3706_n1374#
+ NAND3_38/m1_n2243_n1314# GND NAND3
XNAND3_49 wl[13] VDD comp[13] NAND3_49/a_2506_982# comp[14] comp[12] NAND3_49/m1_n3706_n1374#
+ NAND3_49/m1_n2243_n1314# GND NAND3
XNAND3_7 wl[55] VDD comp[55] NAND3_7/a_2506_982# comp[56] comp[54] NAND3_7/m1_n3706_n1374#
+ NAND3_7/m1_n2243_n1314# GND NAND3
XNAND3_17 wl[45] VDD comp[45] NAND3_17/a_2506_982# comp[46] comp[44] NAND3_17/m1_n3706_n1374#
+ NAND3_17/m1_n2243_n1314# GND NAND3
XNAND3_28 wl[34] VDD comp[34] NAND3_28/a_2506_982# comp[35] comp[33] NAND3_28/m1_n3706_n1374#
+ NAND3_28/m1_n2243_n1314# GND NAND3
XNAND3_39 wl[23] VDD comp[23] NAND3_39/a_2506_982# comp[24] comp[22] NAND3_39/m1_n3706_n1374#
+ NAND3_39/m1_n2243_n1314# GND NAND3
XNAND3_8 wl[54] VDD comp[54] NAND3_8/a_2506_982# comp[55] comp[53] NAND3_8/m1_n3706_n1374#
+ NAND3_8/m1_n2243_n1314# GND NAND3
XNAND3_18 wl[44] VDD comp[44] NAND3_18/a_2506_982# comp[45] comp[43] NAND3_18/m1_n3706_n1374#
+ NAND3_18/m1_n2243_n1314# GND NAND3
XNAND3_29 wl[33] VDD comp[33] NAND3_29/a_2506_982# comp[34] comp[32] NAND3_29/m1_n3706_n1374#
+ NAND3_29/m1_n2243_n1314# GND NAND3
XNAND3_9 wl[53] VDD comp[53] NAND3_9/a_2506_982# comp[54] comp[52] NAND3_9/m1_n3706_n1374#
+ NAND3_9/m1_n2243_n1314# GND NAND3
XNAND3_19 wl[43] VDD comp[43] NAND3_19/a_2506_982# comp[44] comp[42] NAND3_19/m1_n3706_n1374#
+ NAND3_19/m1_n2243_n1314# GND NAND3
C0 NAND3_1/a_2506_982# comp[60] 0.11685f
C1 NAND3_17/m1_n2243_n1314# NAND3_16/m1_n2243_n1314# 0.05788f
C2 VDD NAND3_59/a_2506_982# 0.0187f
C3 NAND3_55/a_2506_982# comp[7] 0.03572f
C4 NAND3_16/a_2506_982# comp[45] 0.03971f
C5 comp[10] NAND3_51/a_2506_982# 0.07787f
C6 VDD wl[58] 0.22473f
C7 comp[12] NAND3_49/a_2506_982# 0.11685f
C8 VDD wl[13] 0.22473f
C9 VDD NAND3_28/a_2506_982# 0.0187f
C10 comp[25] NAND3_37/a_2506_982# 0.03572f
C11 comp[42] NAND3_20/a_2506_982# 0.15634f
C12 NAND3_18/m1_n3706_n1374# comp[43] 0.02583f
C13 comp[36] NAND3_26/a_2506_982# 0.15634f
C14 comp[10] VDD 0.16989f
C15 VDD NAND3_36/a_2506_982# 0.0187f
C16 VDD wl[48] 0.22473f
C17 comp[35] comp[34] 1.99996f
C18 comp[21] comp[20] 0.89041f
C19 VDD comp[24] 0.27044f
C20 comp[44] comp[43] 2.06039f
C21 comp[7] comp[5] 0.35414f
C22 comp[13] comp[15] 0.37155f
C23 NAND3_52/m1_n3706_n1374# comp[9] 0.05127f
C24 comp[31] NAND3_30/a_2506_982# 0.03094f
C25 wl[40] VDD 0.22473f
C26 NAND3_32/m1_n3706_n1374# NAND3_33/m1_n3706_n1374# 0.05965f
C27 NAND3_2/a_2506_982# VDD 0.0187f
C28 NAND3_43/m1_n3706_n1374# NAND3_42/m1_n3706_n1374# 0.05965f
C29 wl[2] VDD 0.22473f
C30 NAND3_18/m1_n2243_n1314# NAND3_19/m1_n2243_n1314# 0.05788f
C31 comp[16] comp[15] 2.06116f
C32 VDD comp[35] 0.01693f
C33 comp[50] comp[49] 2.06039f
C34 comp[33] NAND3_29/m1_n3706_n1374# 0.05157f
C35 comp[16] NAND3_45/a_2506_982# 0.07787f
C36 comp[35] comp[37] 0.35414f
C37 comp[3] NAND3_60/a_2506_982# 0.11803f
C38 NAND3_58/a_2506_982# VDD 0.0187f
C39 NAND3_44/m1_n3706_n1374# comp[18] 0.05127f
C40 comp[20] comp[19] 2.06039f
C41 NAND3_37/a_2506_982# comp[24] 0.11685f
C42 comp[33] comp[32] 0.89041f
C43 VDD wl[54] 0.22473f
C44 NAND3_46/m1_n3706_n1374# comp[15] 0.05127f
C45 comp[24] comp[22] 0.01581f
C46 comp[60] comp[59] 0.83447f
C47 wl[4] VDD 0.22473f
C48 comp[14] comp[13] 2.06039f
C49 NAND3_10/a_2506_982# comp[51] 0.03971f
C50 NAND3_2/m1_n2243_n1314# NAND3_3/m1_n2243_n1314# 0.05788f
C51 NAND3_48/m1_n2243_n1314# NAND3_49/m1_n2243_n1314# 0.05788f
C52 NAND3_35/a_2506_982# VDD 0.0187f
C53 VDD comp[57] 0.27044f
C54 comp[1] comp[2] 2.06039f
C55 comp[28] NAND3_33/a_2506_982# 0.07787f
C56 NAND3_17/a_2506_982# comp[45] 0.15634f
C57 VDD NAND3_30/a_2506_982# 0.0187f
C58 NAND3_3/m1_n3706_n1374# NAND3_2/m1_n3706_n1374# 0.05965f
C59 NAND3_57/a_2506_982# VDD 0.0187f
C60 comp[14] comp[16] 0.01346f
C61 comp[61] NAND3_0/m1_n3706_n1374# 0.02583f
C62 comp[21] VDD 0.27044f
C63 wl[28] VDD 0.22473f
C64 comp[60] comp[58] 0.01581f
C65 VDD NAND3_33/a_2506_982# 0.0187f
C66 NAND3_53/a_2506_982# comp[9] 0.15634f
C67 comp[31] comp[29] 0.35414f
C68 NAND3_10/m1_n2243_n1314# NAND3_11/m1_n2243_n1314# 0.05788f
C69 NAND3_57/a_2506_982# comp[6] 0.03831f
C70 comp[39] comp[40] 2.06116f
C71 comp[30] NAND3_33/a_2506_982# 0.03831f
C72 VDD comp[43] 0.02359f
C73 VDD NAND3_25/a_2506_982# 0.0187f
C74 comp[17] VDD 0.01693f
C75 NAND3_10/a_2506_982# comp[52] 0.07771f
C76 VDD comp[4] 0.16989f
C77 NAND3_8/a_2506_982# comp[54] 0.15634f
C78 NAND3_10/a_2506_982# VDD 0.0187f
C79 NAND3_25/a_2506_982# comp[37] 0.03572f
C80 comp[41] comp[43] 0.35414f
C81 comp[27] comp[26] 0.89041f
C82 comp[16] comp[18] 0.01581f
C83 comp[53] comp[55] 0.35414f
C84 NAND3_7/m1_n3706_n1374# comp[55] 0.02613f
C85 comp[6] comp[4] 0.01581f
C86 NAND3_0/a_2506_982# VDD 0.01126f
C87 VDD comp[19] 0.02359f
C88 comp[58] comp[59] 1.99996f
C89 comp[21] comp[22] 2.06116f
C90 comp[27] comp[25] 0.37155f
C91 comp[29] comp[28] 1.99996f
C92 VDD NAND3_8/a_2506_982# 0.0187f
C93 NAND3_43/m1_n2243_n1314# NAND3_42/m1_n2243_n1314# 0.05788f
C94 comp[31] comp[32] 2.06039f
C95 NAND3_46/m1_n3706_n1374# NAND3_47/m1_n3706_n1374# 0.05965f
C96 comp[58] NAND3_4/a_2506_982# 0.07771f
C97 comp[46] comp[45] 2.06116f
C98 comp[29] VDD 0.01693f
C99 comp[35] comp[36] 0.83447f
C100 NAND3_41/a_2506_982# VDD 0.0187f
C101 NAND3_51/m1_n2243_n1314# NAND3_50/m1_n2243_n1314# 0.05788f
C102 comp[29] comp[30] 0.83447f
C103 comp[61] NAND3_1/m1_n3706_n1374# 0.02613f
C104 VDD wl[23] 0.22474f
C105 NAND3_53/m1_n2243_n1314# NAND3_52/m1_n2243_n1314# 0.05788f
C106 comp[10] NAND3_52/a_2506_982# 0.07771f
C107 comp[8] comp[7] 2.06039f
C108 NAND3_30/m1_n2243_n1314# NAND3_31/m1_n2243_n1314# 0.05788f
C109 comp[42] comp[43] 1.99041f
C110 m1_n4168_2156# comp[1] 1.76835f
C111 comp[34] comp[32] 0.01346f
C112 VDD NAND3_40/a_2506_982# 0.0187f
C113 wl[15] VDD 0.22474f
C114 VDD NAND3_19/a_2506_982# 0.0187f
C115 NAND3_28/m1_n3706_n1374# NAND3_29/m1_n3706_n1374# 0.05965f
C116 VDD wl[37] 0.22474f
C117 comp[49] comp[47] 0.35414f
C118 wl[11] VDD 0.22474f
C119 comp[49] comp[51] 0.37155f
C120 NAND3_11/a_2506_982# comp[51] 0.15634f
C121 NAND3_9/m1_n2243_n1314# NAND3_8/m1_n2243_n1314# 0.05788f
C122 VDD wl[43] 0.22473f
C123 comp[23] comp[25] 0.35414f
C124 comp[27] NAND3_36/a_2506_982# 0.11803f
C125 VDD comp[32] 0.01693f
C126 NAND3_1/a_2506_982# VDD 0.0187f
C127 comp[39] NAND3_23/a_2506_982# 0.15634f
C128 NAND3_6/m1_n3706_n1374# comp[55] 0.02583f
C129 VDD wl[45] 0.22474f
C130 NAND3_21/a_2506_982# VDD 0.0187f
C131 comp[17] comp[15] 0.06677f
C132 NAND3_12/a_2506_982# comp[49] 0.03094f
C133 NAND3_5/m1_n3706_n1374# NAND3_4/m1_n3706_n1374# 0.05965f
C134 NAND3_25/a_2506_982# comp[36] 0.11685f
C135 NAND3_40/a_2506_982# comp[22] 0.07771f
C136 VDD comp[49] 0.02359f
C137 VDD NAND3_11/a_2506_982# 0.0187f
C138 NAND3_18/a_2506_982# comp[45] 0.11803f
C139 comp[3] NAND3_59/m1_n3706_n1374# 0.05157f
C140 wl[62] VDD 0.22332f
C141 comp[3] VDD 0.27044f
C142 NAND3_29/m1_n2243_n1314# NAND3_28/m1_n2243_n1314# 0.05788f
C143 comp[42] NAND3_19/a_2506_982# 0.11685f
C144 comp[54] comp[55] 1.99041f
C145 comp[60] NAND3_3/a_2506_982# 0.03831f
C146 VDD NAND3_24/a_2506_982# 0.0187f
C147 NAND3_6/m1_n3706_n1374# NAND3_7/m1_n3706_n1374# 0.05965f
C148 comp[60] VDD 0.27044f
C149 comp[34] NAND3_27/a_2506_982# 0.07787f
C150 NAND3_24/a_2506_982# comp[37] 0.03094f
C151 comp[50] comp[51] 0.89041f
C152 VDD wl[60] 0.22473f
C153 VDD wl[7] 0.22474f
C154 NAND3_21/a_2506_982# comp[42] 0.03831f
C155 NAND3_53/a_2506_982# VDD 0.0187f
C156 comp[23] comp[24] 0.83447f
C157 NAND3_35/a_2506_982# comp[27] 0.15634f
C158 VDD comp[55] 0.02359f
C159 NAND3_34/m1_n3706_n1374# NAND3_35/m1_n3706_n1374# 0.05965f
C160 comp[21] NAND3_40/m1_n3706_n1374# 0.05127f
C161 VDD NAND3_27/a_2506_982# 0.0187f
C162 NAND3_56/m1_n2243_n1314# NAND3_57/m1_n2243_n1314# 0.05788f
C163 NAND3_13/a_2506_982# comp[49] 0.03572f
C164 wl[9] VDD 0.22473f
C165 comp[13] NAND3_48/m1_n3706_n1374# 0.02583f
C166 comp[17] comp[18] 0.83447f
C167 comp[53] comp[51] 0.06677f
C168 comp[33] comp[31] 0.37155f
C169 comp[50] comp[52] 0.01346f
C170 VDD wl[49] 0.22474f
C171 NAND3_61/m1_n3706_n1374# comp[1] 0.02613f
C172 comp[53] comp[54] 0.83447f
C173 NAND3_47/m1_n2243_n1314# NAND3_46/m1_n2243_n1314# 0.05788f
C174 VDD wl[35] 0.22474f
C175 VDD comp[59] 0.01693f
C176 VDD NAND3_60/a_2506_982# 0.0187f
C177 VDD NAND3_56/a_2506_982# 0.0187f
C178 VDD comp[50] 0.01693f
C179 VDD wl[34] 0.22474f
C180 VDD wl[14] 0.22473f
C181 NAND3_19/m1_n3706_n1374# comp[43] 0.02613f
C182 comp[60] NAND3_2/m1_n3706_n1374# 0.05127f
C183 VDD wl[24] 0.22473f
C184 comp[9] VDD 0.27044f
C185 NAND3_3/a_2506_982# comp[58] 0.07787f
C186 comp[48] NAND3_15/m1_n3706_n1374# 0.05127f
C187 comp[13] comp[11] 0.35414f
C188 comp[6] NAND3_56/a_2506_982# 0.15634f
C189 VDD NAND3_4/a_2506_982# 0.0187f
C190 comp[19] comp[18] 1.99041f
C191 VDD comp[38] 0.01693f
C192 comp[12] comp[13] 1.99041f
C193 VDD NAND3_44/a_2506_982# 0.0187f
C194 NAND3_58/m1_n3706_n1374# comp[3] 0.05127f
C195 NAND3_14/m1_n3706_n1374# comp[48] 0.05127f
C196 comp[58] VDD 0.16989f
C197 comp[53] comp[52] 1.99996f
C198 comp[33] comp[34] 2.06116f
C199 comp[38] comp[37] 2.06039f
C200 VDD NAND3_5/a_2506_982# 0.0187f
C201 comp[26] comp[25] 2.06039f
C202 comp[12] comp[11] 0.83447f
C203 VDD comp[53] 0.01693f
C204 VDD NAND3_62/a_2506_982# 0.0187f
C205 comp[4] comp[5] 1.99996f
C206 NAND3_32/m1_n2243_n1314# NAND3_33/m1_n2243_n1314# 0.05788f
C207 NAND3_43/a_2506_982# comp[19] 0.03572f
C208 NAND3_45/m1_n3706_n1374# comp[18] 0.05127f
C209 comp[4] comp[2] 0.01346f
C210 comp[29] comp[27] 0.06677f
C211 comp[21] comp[23] 0.06677f
C212 comp[56] comp[57] 0.89041f
C213 comp[33] VDD 0.27044f
C214 VDD NAND3_48/a_2506_982# 0.0187f
C215 comp[33] NAND3_28/m1_n3706_n1374# 0.05127f
C216 NAND3_32/a_2506_982# VDD 0.0187f
C217 wl[8] VDD 0.22473f
C218 comp[39] NAND3_22/m1_n3706_n1374# 0.05127f
C219 NAND3_23/m1_n2243_n1314# NAND3_22/m1_n2243_n1314# 0.05788f
C220 comp[24] NAND3_38/a_2506_982# 0.15634f
C221 comp[49] comp[48] 1.99041f
C222 VDD wl[10] 0.22473f
C223 NAND3_32/a_2506_982# comp[30] 0.15634f
C224 VDD wl[39] 0.22474f
C225 NAND3_45/m1_n2243_n1314# NAND3_44/m1_n2243_n1314# 0.05788f
C226 NAND3_21/a_2506_982# comp[40] 0.07787f
C227 NAND3_34/m1_n3706_n1374# comp[27] 0.05127f
C228 comp[10] comp[8] 0.01346f
C229 VDD NAND3_39/a_2506_982# 0.0187f
C230 wl[59] VDD 0.22473f
C231 VDD wl[12] 0.22473f
C232 comp[10] comp[11] 1.99996f
C233 comp[36] NAND3_27/a_2506_982# 0.03831f
C234 comp[10] comp[12] 0.01581f
C235 NAND3_46/a_2506_982# VDD 0.0187f
C236 VDD NAND3_22/a_2506_982# 0.0187f
C237 VDD comp[44] 0.01693f
C238 VDD wl[18] 0.22473f
C239 NAND3_36/a_2506_982# comp[25] 0.03094f
C240 NAND3_41/m1_n3706_n1374# NAND3_40/m1_n3706_n1374# 0.05965f
C241 comp[57] NAND3_4/m1_n3706_n1374# 0.05127f
C242 comp[12] NAND3_51/m1_n3706_n1374# 0.05127f
C243 VDD NAND3_50/a_2506_982# 0.0187f
C244 comp[20] VDD 0.01693f
C245 VDD wl[36] 0.22474f
C246 NAND3_7/m1_n2243_n1314# NAND3_6/m1_n2243_n1314# 0.05788f
C247 NAND3_54/m1_n3706_n1374# comp[7] 0.02583f
C248 comp[25] comp[24] 1.99041f
C249 comp[24] NAND3_39/m1_n3706_n1374# 0.05127f
C250 NAND3_5/m1_n3706_n1374# comp[57] 0.05157f
C251 wl[50] VDD 0.22473f
C252 NAND3_54/a_2506_982# comp[9] 0.11803f
C253 NAND3_18/a_2506_982# comp[43] 0.03094f
C254 NAND3_39/a_2506_982# comp[22] 0.07787f
C255 NAND3_9/m1_n3706_n1374# comp[54] 0.05127f
C256 comp[31] VDD 0.02359f
C257 NAND3_12/a_2506_982# comp[51] 0.11803f
C258 NAND3_54/m1_n2243_n1314# NAND3_55/m1_n2243_n1314# 0.05788f
C259 comp[21] NAND3_42/a_2506_982# 0.11803f
C260 comp[31] comp[30] 1.99041f
C261 comp[52] comp[51] 2.06116f
C262 comp[54] comp[52] 0.01581f
C263 comp[57] NAND3_6/a_2506_982# 0.11803f
C264 VDD comp[47] 0.01693f
C265 VDD comp[51] 0.27044f
C266 NAND3_48/a_2506_982# comp[15] 0.11803f
C267 VDD comp[54] 0.27044f
C268 NAND3_51/a_2506_982# VDD 0.0187f
C269 NAND3_48/m1_n3706_n1374# NAND3_49/m1_n3706_n1374# 0.05965f
C270 VDD wl[21] 0.22474f
C271 VDD comp[34] 0.16989f
C272 comp[20] comp[22] 0.01346f
C273 comp[61] comp[62] 1.96698f
C274 NAND3_52/a_2506_982# comp[9] 0.03971f
C275 NAND3_47/a_2506_982# VDD 0.0187f
C276 comp[3] comp[5] 0.06677f
C277 comp[13] NAND3_49/m1_n3706_n1374# 0.02613f
C278 comp[45] comp[43] 0.37155f
C279 NAND3_12/a_2506_982# VDD 0.0187f
C280 VDD comp[28] 0.16989f
C281 NAND3_3/a_2506_982# VDD 0.0187f
C282 comp[3] comp[2] 0.89041f
C283 comp[38] comp[40] 0.01346f
C284 VDD wl[22] 0.22473f
C285 VDD comp[52] 0.16989f
C286 NAND3_55/m1_n3706_n1374# comp[7] 0.02613f
C287 wl[17] VDD 0.22474f
C288 NAND3_16/m1_n3706_n1374# comp[45] 0.05127f
C289 NAND3_42/a_2506_982# comp[19] 0.03094f
C290 comp[33] NAND3_29/a_2506_982# 0.15634f
C291 comp[30] comp[28] 0.01581f
C292 comp[25] NAND3_37/m1_n3706_n1374# 0.02613f
C293 comp[42] NAND3_20/m1_n3706_n1374# 0.05127f
C294 NAND3_45/m1_n3706_n1374# NAND3_44/m1_n3706_n1374# 0.05965f
C295 VDD comp[37] 0.02359f
C296 VDD comp[30] 0.27044f
C297 VDD comp[41] 0.01693f
C298 comp[6] VDD 0.27044f
C299 NAND3_44/a_2506_982# comp[18] 0.15634f
C300 comp[36] NAND3_26/m1_n3706_n1374# 0.05127f
C301 VDD wl[61] 0.22474f
C302 comp[16] comp[17] 1.99996f
C303 NAND3_46/a_2506_982# comp[15] 0.03971f
C304 NAND3_0/m1_n2243_n1314# NAND3_1/m1_n2243_n1314# 0.05788f
C305 NAND3_35/m1_n2243_n1314# NAND3_34/m1_n2243_n1314# 0.05788f
C306 comp[61] NAND3_0/a_2506_982# 0.032f
C307 NAND3_36/m1_n3706_n1374# comp[25] 0.02583f
C308 VDD NAND3_37/a_2506_982# 0.0187f
C309 VDD NAND3_49/a_2506_982# 0.0187f
C310 VDD comp[22] 0.16989f
C311 comp[31] NAND3_30/m1_n3706_n1374# 0.02583f
C312 comp[56] comp[55] 2.06039f
C313 NAND3_13/a_2506_982# VDD 0.0187f
C314 VDD NAND3_61/a_2506_982# 0.0187f
C315 comp[3] comp[1] 0.37155f
C316 VDD comp[42] 0.27044f
C317 NAND3_52/m1_n3706_n1374# NAND3_53/m1_n3706_n1374# 0.05965f
C318 VDD NAND3_16/a_2506_982# 0.0187f
C319 VDD wl[25] 0.22473f
C320 NAND3_58/m1_n3706_n1374# NAND3_59/m1_n3706_n1374# 0.05965f
C321 wl[31] VDD 0.22474f
C322 NAND3_7/a_2506_982# comp[55] 0.03572f
C323 comp[9] comp[7] 0.37155f
C324 comp[42] comp[41] 0.83447f
C325 comp[40] NAND3_22/a_2506_982# 0.07771f
C326 NAND3_18/m1_n3706_n1374# NAND3_19/m1_n3706_n1374# 0.05965f
C327 comp[34] comp[36] 0.01581f
C328 NAND3_47/a_2506_982# comp[15] 0.15634f
C329 VDD wl[26] 0.22473f
C330 comp[47] comp[48] 0.83447f
C331 NAND3_10/m1_n3706_n1374# comp[51] 0.05127f
C332 comp[56] comp[58] 0.01346f
C333 VDD wl[51] 0.22474f
C334 NAND3_17/m1_n3706_n1374# comp[45] 0.05157f
C335 VDD comp[15] 0.27044f
C336 VDD wl[52] 0.22474f
C337 VDD NAND3_45/a_2506_982# 0.0187f
C338 VDD comp[36] 0.27044f
C339 NAND3_13/m1_n3706_n1374# NAND3_12/m1_n3706_n1374# 0.05965f
C340 VDD wl[42] 0.22473f
C341 comp[61] NAND3_1/a_2506_982# 0.03572f
C342 NAND3_57/m1_n3706_n1374# comp[6] 0.05127f
C343 NAND3_60/a_2506_982# comp[1] 0.03094f
C344 NAND3_54/a_2506_982# VDD 0.0187f
C345 comp[36] comp[37] 1.99041f
C346 comp[30] NAND3_33/m1_n3706_n1374# 0.05127f
C347 NAND3_34/a_2506_982# comp[28] 0.07771f
C348 NAND3_8/m1_n3706_n1374# comp[54] 0.05127f
C349 VDD comp[48] 0.27044f
C350 VDD NAND3_15/a_2506_982# 0.0187f
C351 NAND3_25/m1_n2243_n1314# NAND3_24/m1_n2243_n1314# 0.05788f
C352 NAND3_25/m1_n3706_n1374# comp[37] 0.02613f
C353 NAND3_34/a_2506_982# VDD 0.0187f
C354 VDD NAND3_29/a_2506_982# 0.0187f
C355 NAND3_8/m1_n3706_n1374# NAND3_9/m1_n3706_n1374# 0.05965f
C356 NAND3_58/a_2506_982# comp[4] 0.07771f
C357 VDD NAND3_14/a_2506_982# 0.0187f
C358 NAND3_31/m1_n3706_n1374# comp[31] 0.02613f
C359 VDD wl[33] 0.22474f
C360 comp[14] VDD 0.01693f
C361 comp[46] comp[44] 0.01346f
C362 NAND3_6/a_2506_982# comp[55] 0.03094f
C363 NAND3_52/a_2506_982# VDD 0.0187f
C364 comp[39] NAND3_24/a_2506_982# 0.11803f
C365 NAND3_53/m1_n3706_n1374# comp[9] 0.05157f
C366 VDD comp[40] 0.16989f
C367 NAND3_57/a_2506_982# comp[4] 0.07787f
C368 VDD wl[38] 0.22473f
C369 NAND3_62/a_2506_982# m1_n4168_2156# 0.11729f
C370 VDD NAND3_17/a_2506_982# 0.0187f
C371 comp[61] comp[60] 1.99041f
C372 NAND3_21/m1_n3706_n1374# NAND3_20/m1_n3706_n1374# 0.05965f
C373 comp[40] comp[41] 1.99996f
C374 VDD NAND3_55/a_2506_982# 0.0187f
C375 comp[27] comp[28] 2.06116f
C376 VDD comp[18] 0.27044f
C377 comp[3] NAND3_59/a_2506_982# 0.15634f
C378 NAND3_36/m1_n3706_n1374# NAND3_37/m1_n3706_n1374# 0.05965f
C379 NAND3_21/m1_n2243_n1314# NAND3_20/m1_n2243_n1314# 0.05788f
C380 NAND3_13/a_2506_982# comp[48] 0.11685f
C381 comp[21] comp[19] 0.37155f
C382 comp[9] comp[8] 0.89041f
C383 comp[27] VDD 0.27044f
C384 comp[6] NAND3_55/a_2506_982# 0.11685f
C385 wl[27] VDD 0.22473f
C386 comp[46] comp[47] 1.99996f
C387 VDD wl[44] 0.22473f
C388 NAND3_43/a_2506_982# VDD 0.0187f
C389 NAND3_27/m1_n3706_n1374# NAND3_26/m1_n3706_n1374# 0.05965f
C390 comp[9] comp[11] 0.06677f
C391 comp[17] comp[19] 0.35414f
C392 NAND3_11/m1_n3706_n1374# comp[51] 0.05157f
C393 VDD wl[53] 0.22474f
C394 comp[61] comp[59] 0.35414f
C395 comp[21] NAND3_41/a_2506_982# 0.15634f
C396 comp[39] NAND3_23/m1_n3706_n1374# 0.05157f
C397 NAND3_39/m1_n2243_n1314# NAND3_38/m1_n2243_n1314# 0.05788f
C398 comp[39] comp[38] 0.89041f
C399 NAND3_60/m1_n3706_n1374# comp[1] 0.02583f
C400 comp[42] comp[40] 0.01581f
C401 VDD comp[5] 0.01693f
C402 VDD comp[2] 0.01693f
C403 NAND3_12/m1_n3706_n1374# comp[49] 0.02583f
C404 comp[21] NAND3_40/a_2506_982# 0.03971f
C405 VDD comp[46] 0.16989f
C406 NAND3_59/m1_n2243_n1314# NAND3_58/m1_n2243_n1314# 0.05788f
C407 comp[6] comp[5] 0.83447f
C408 comp[13] NAND3_48/a_2506_982# 0.03094f
C409 wl[0] VDD 0.22473f
C410 NAND3_23/m1_n3706_n1374# NAND3_22/m1_n3706_n1374# 0.05965f
C411 NAND3_7/a_2506_982# comp[54] 0.11685f
C412 VDD comp[7] 0.02359f
C413 comp[14] comp[15] 0.89041f
C414 VDD comp[23] 0.01693f
C415 NAND3_19/a_2506_982# comp[43] 0.03572f
C416 comp[60] NAND3_2/a_2506_982# 0.15634f
C417 comp[60] NAND3_3/m1_n3706_n1374# 0.05127f
C418 comp[6] comp[7] 1.99041f
C419 comp[48] NAND3_15/a_2506_982# 0.03831f
C420 comp[56] VDD 0.01693f
C421 VDD NAND3_23/a_2506_982# 0.0187f
C422 VDD wl[3] 0.22474f
C423 VDD wl[30] 0.22473f
C424 NAND3_58/a_2506_982# comp[3] 0.03971f
C425 comp[12] NAND3_50/m1_n3706_n1374# 0.05127f
C426 NAND3_14/a_2506_982# comp[48] 0.15634f
C427 comp[21] NAND3_41/m1_n3706_n1374# 0.05157f
C428 wl[32] VDD 0.22473f
C429 NAND3_41/m1_n2243_n1314# NAND3_40/m1_n2243_n1314# 0.05788f
C430 NAND3_24/m1_n3706_n1374# comp[37] 0.02583f
C431 VDD NAND3_7/a_2506_982# 0.0187f
C432 wl[41] VDD 0.22474f
C433 comp[10] comp[9] 2.06116f
C434 NAND3_14/m1_n2243_n1314# NAND3_15/m1_n2243_n1314# 0.05788f
C435 comp[45] comp[44] 0.89041f
C436 NAND3_47/m1_n3706_n1374# comp[15] 0.05157f
C437 NAND3_21/m1_n3706_n1374# comp[42] 0.05127f
C438 NAND3_45/a_2506_982# comp[18] 0.03831f
C439 NAND3_35/m1_n3706_n1374# comp[27] 0.05157f
C440 VDD wl[55] 0.22474f
C441 comp[31] NAND3_31/a_2506_982# 0.03572f
C442 NAND3_39/m1_n3706_n1374# NAND3_38/m1_n3706_n1374# 0.05965f
C443 NAND3_17/m1_n3706_n1374# NAND3_16/m1_n3706_n1374# 0.05965f
C444 comp[23] comp[22] 1.99996f
C445 comp[33] NAND3_28/a_2506_982# 0.03971f
C446 comp[46] NAND3_16/a_2506_982# 0.07771f
C447 VDD comp[1] 0.03016f
C448 NAND3_31/m1_n3706_n1374# NAND3_30/m1_n3706_n1374# 0.05965f
C449 NAND3_13/m1_n3706_n1374# comp[49] 0.02613f
C450 comp[16] NAND3_46/a_2506_982# 0.07771f
C451 wl[1] VDD 0.22474f
C452 comp[39] NAND3_22/a_2506_982# 0.03971f
C453 VDD wl[29] 0.22474f
C454 comp[12] NAND3_50/a_2506_982# 0.15634f
C455 VDD NAND3_18/a_2506_982# 0.0187f
C456 NAND3_12/m1_n2243_n1314# NAND3_13/m1_n2243_n1314# 0.05788f
C457 comp[3] comp[4] 2.06116f
C458 VDD m1_n4168_2156# 0.29947f
C459 NAND3_34/a_2506_982# comp[27] 0.03971f
C460 comp[57] comp[55] 0.37155f
C461 comp[6] NAND3_56/m1_n3706_n1374# 0.05127f
C462 comp[47] comp[45] 0.06677f
C463 NAND3_36/m1_n2243_n1314# NAND3_37/m1_n2243_n1314# 0.05788f
C464 VDD wl[56] 0.22473f
C465 VDD NAND3_38/a_2506_982# 0.0187f
C466 NAND3_14/m1_n3706_n1374# NAND3_15/m1_n3706_n1374# 0.05965f
C467 VDD NAND3_26/a_2506_982# 0.0187f
C468 NAND3_42/a_2506_982# VDD 0.0187f
C469 comp[57] comp[59] 0.06677f
C470 NAND3_31/a_2506_982# VDD 0.0187f
C471 NAND3_51/m1_n3706_n1374# NAND3_50/m1_n3706_n1374# 0.05965f
C472 NAND3_43/m1_n3706_n1374# comp[19] 0.02613f
C473 comp[33] comp[35] 0.06677f
C474 NAND3_31/a_2506_982# comp[30] 0.11685f
C475 NAND3_0/m1_n3706_n1374# NAND3_1/m1_n3706_n1374# 0.05965f
C476 NAND3_61/m1_n3706_n1374# NAND3_60/m1_n3706_n1374# 0.05965f
C477 comp[57] NAND3_4/a_2506_982# 0.03971f
C478 comp[12] NAND3_51/a_2506_982# 0.03831f
C479 VDD NAND3_6/a_2506_982# 0.0187f
C480 NAND3_61/a_2506_982# comp[1] 0.03572f
C481 VDD wl[57] 0.22474f
C482 NAND3_54/m1_n3706_n1374# NAND3_55/m1_n3706_n1374# 0.05965f
C483 comp[26] comp[28] 0.01346f
C484 VDD comp[45] 0.27044f
C485 comp[46] NAND3_15/a_2506_982# 0.07787f
C486 comp[46] comp[48] 0.01581f
C487 NAND3_54/a_2506_982# comp[7] 0.03094f
C488 comp[19] NAND3_42/m1_n3706_n1374# 0.02583f
C489 comp[24] NAND3_39/a_2506_982# 0.03831f
C490 VDD comp[8] 0.01693f
C491 comp[58] comp[57] 2.06116f
C492 NAND3_5/a_2506_982# comp[57] 0.15634f
C493 comp[24] NAND3_38/m1_n3706_n1374# 0.05127f
C494 VDD comp[13] 0.02359f
C495 VDD comp[26] 0.01693f
C496 VDD NAND3_20/a_2506_982# 0.0187f
C497 NAND3_9/a_2506_982# comp[54] 0.03831f
C498 NAND3_10/m1_n3706_n1374# NAND3_11/m1_n3706_n1374# 0.05965f
C499 wl[16] VDD 0.22473f
C500 NAND3_32/m1_n3706_n1374# comp[30] 0.05127f
C501 wl[5] VDD 0.22474f
C502 NAND3_61/a_2506_982# m1_n4168_2156# 0.11685f
C503 NAND3_43/a_2506_982# comp[18] 0.11685f
C504 VDD comp[11] 0.01693f
C505 wl[19] VDD 0.22474f
C506 comp[12] VDD 0.27044f
C507 comp[16] VDD 0.16989f
C508 VDD comp[39] 0.27044f
C509 NAND3_25/m1_n3706_n1374# NAND3_24/m1_n3706_n1374# 0.05965f
C510 NAND3_26/m1_n2243_n1314# NAND3_27/m1_n2243_n1314# 0.05788f
C511 VDD wl[47] 0.22474f
C512 VDD comp[25] 0.02359f
C513 comp[61] VDD 0.02049f
C514 comp[39] comp[37] 0.37155f
C515 comp[33] NAND3_30/a_2506_982# 0.11803f
C516 comp[39] comp[41] 0.06677f
C517 VDD wl[6] 0.22473f
C518 NAND3_9/a_2506_982# comp[52] 0.07787f
C519 VDD wl[46] 0.22473f
C520 comp[34] NAND3_28/a_2506_982# 0.07771f
C521 VDD NAND3_9/a_2506_982# 0.0187f
C522 comp[36] NAND3_27/m1_n3706_n1374# 0.05127f
C523 NAND3_60/m1_n2243_n1314# NAND3_61/m1_n2243_n1314# 0.05788f
C524 wl[20] VDD 0.22473f
C525 NAND3_57/m1_n3706_n1374# NAND3_56/m1_n3706_n1374# 0.05965f
C526 comp[13] NAND3_49/a_2506_982# 0.03572f
C527 NAND3_4/m1_n2243_n1314# NAND3_5/m1_n2243_n1314# 0.05788f
C528 comp[44] GND -1.36228f
C529 NAND3_19/a_n593_982# GND -1.65539f
C530 wl[43] GND 0.36421f
C531 NAND3_19/m1_n3706_n1374# GND -0.40532f
C532 NAND3_19/a_2506_982# GND -2.40355f
C533 NAND3_19/m1_n2243_n1314# GND -0.4071f
C534 comp[54] GND -2.36707f
C535 NAND3_9/a_n593_982# GND -1.65539f
C536 wl[53] GND 0.3642f
C537 NAND3_9/m1_n3706_n1374# GND -0.40532f
C538 NAND3_9/a_2506_982# GND -2.40355f
C539 NAND3_9/m1_n2243_n1314# GND -0.4071f
C540 comp[34] GND -2.08432f
C541 NAND3_29/a_n593_982# GND -1.65539f
C542 wl[33] GND 0.3642f
C543 NAND3_29/m1_n3706_n1374# GND -0.40532f
C544 NAND3_29/a_2506_982# GND -2.40355f
C545 NAND3_29/m1_n2243_n1314# GND -0.4071f
C546 comp[45] GND -2.09538f
C547 NAND3_18/a_n593_982# GND -1.65539f
C548 wl[44] GND 0.36421f
C549 NAND3_18/m1_n3706_n1374# GND -0.40532f
C550 NAND3_18/a_2506_982# GND -2.40355f
C551 NAND3_18/m1_n2243_n1314# GND -0.4071f
C552 comp[55] GND -1.70542f
C553 NAND3_8/a_n593_982# GND -1.65539f
C554 wl[54] GND 0.36421f
C555 NAND3_8/m1_n3706_n1374# GND -0.40532f
C556 NAND3_8/a_2506_982# GND -2.40355f
C557 NAND3_8/m1_n2243_n1314# GND -0.4071f
C558 comp[24] GND -2.36707f
C559 NAND3_39/a_n593_982# GND -1.65539f
C560 wl[23] GND 0.3642f
C561 NAND3_39/m1_n3706_n1374# GND -0.40532f
C562 NAND3_39/a_2506_982# GND -2.40355f
C563 NAND3_39/m1_n2243_n1314# GND -0.4071f
C564 comp[35] GND -1.03412f
C565 NAND3_28/a_n593_982# GND -1.65539f
C566 wl[34] GND 0.3642f
C567 NAND3_28/m1_n3706_n1374# GND -0.40532f
C568 NAND3_28/a_2506_982# GND -2.40355f
C569 NAND3_28/m1_n2243_n1314# GND -0.4071f
C570 comp[46] GND -2.08432f
C571 NAND3_17/a_n593_982# GND -1.65539f
C572 wl[45] GND 0.3642f
C573 NAND3_17/m1_n3706_n1374# GND -0.40532f
C574 NAND3_17/a_2506_982# GND -2.40355f
C575 NAND3_17/m1_n2243_n1314# GND -0.4071f
C576 comp[56] GND -1.36228f
C577 NAND3_7/a_n593_982# GND -1.65539f
C578 wl[55] GND 0.3642f
C579 NAND3_7/m1_n3706_n1374# GND -0.40532f
C580 NAND3_7/a_2506_982# GND -2.40355f
C581 NAND3_7/m1_n2243_n1314# GND -0.4071f
C582 comp[14] GND -1.36228f
C583 NAND3_49/a_n593_982# GND -1.65539f
C584 wl[13] GND 0.36421f
C585 NAND3_49/m1_n3706_n1374# GND -0.40532f
C586 NAND3_49/a_2506_982# GND -2.40355f
C587 NAND3_49/m1_n2243_n1314# GND -0.4071f
C588 comp[25] GND -1.70542f
C589 NAND3_38/a_n593_982# GND -1.65539f
C590 wl[24] GND 0.36421f
C591 NAND3_38/m1_n3706_n1374# GND -0.40532f
C592 NAND3_38/a_2506_982# GND -2.40355f
C593 NAND3_38/m1_n2243_n1314# GND -0.4071f
C594 comp[36] GND -2.36707f
C595 NAND3_27/a_n593_982# GND -1.65539f
C596 wl[35] GND 0.3642f
C597 NAND3_27/m1_n3706_n1374# GND -0.40532f
C598 NAND3_27/a_2506_982# GND -2.40355f
C599 NAND3_27/m1_n2243_n1314# GND -0.4071f
C600 comp[47] GND -1.03412f
C601 NAND3_16/a_n593_982# GND -1.65539f
C602 wl[46] GND 0.36421f
C603 NAND3_16/m1_n3706_n1374# GND -0.40532f
C604 NAND3_16/a_2506_982# GND -2.40355f
C605 NAND3_16/m1_n2243_n1314# GND -0.4071f
C606 comp[57] GND -2.09538f
C607 NAND3_6/a_n593_982# GND -1.65539f
C608 wl[56] GND 0.36421f
C609 NAND3_6/m1_n3706_n1374# GND -0.40532f
C610 NAND3_6/a_2506_982# GND -2.40355f
C611 NAND3_6/m1_n2243_n1314# GND -0.4071f
C612 comp[58] GND -2.08432f
C613 NAND3_5/a_n593_982# GND -1.65539f
C614 wl[57] GND 0.3642f
C615 NAND3_5/m1_n3706_n1374# GND -0.40532f
C616 NAND3_5/a_2506_982# GND -2.40355f
C617 NAND3_5/m1_n2243_n1314# GND -0.4071f
C618 comp[4] GND -2.08432f
C619 NAND3_59/a_n593_982# GND -1.65539f
C620 wl[3] GND 0.3642f
C621 NAND3_59/m1_n3706_n1374# GND -0.40532f
C622 NAND3_59/a_2506_982# GND -2.40355f
C623 NAND3_59/m1_n2243_n1314# GND -0.4071f
C624 comp[15] GND -2.09538f
C625 NAND3_48/a_n593_982# GND -1.65539f
C626 wl[14] GND 0.36421f
C627 NAND3_48/m1_n3706_n1374# GND -0.40532f
C628 NAND3_48/a_2506_982# GND -2.40355f
C629 NAND3_48/m1_n2243_n1314# GND -0.4071f
C630 comp[26] GND -1.36228f
C631 NAND3_37/a_n593_982# GND -1.65539f
C632 wl[25] GND 0.36421f
C633 NAND3_37/m1_n3706_n1374# GND -0.40532f
C634 NAND3_37/a_2506_982# GND -2.40355f
C635 NAND3_37/m1_n2243_n1314# GND -0.4071f
C636 comp[37] GND -1.70309f
C637 NAND3_26/a_n593_982# GND -1.65539f
C638 wl[36] GND 0.3642f
C639 NAND3_26/m1_n3706_n1374# GND -0.40532f
C640 NAND3_26/a_2506_982# GND -2.40355f
C641 NAND3_26/m1_n2243_n1314# GND -0.4071f
C642 comp[48] GND -2.36707f
C643 NAND3_15/a_n593_982# GND -1.65539f
C644 wl[47] GND 0.3642f
C645 NAND3_15/m1_n3706_n1374# GND -0.40532f
C646 NAND3_15/a_2506_982# GND -2.40355f
C647 NAND3_15/m1_n2243_n1314# GND -0.4071f
C648 comp[59] GND -1.03412f
C649 NAND3_4/a_n593_982# GND -1.65539f
C650 wl[58] GND 0.36421f
C651 NAND3_4/m1_n3706_n1374# GND -0.40532f
C652 NAND3_4/a_2506_982# GND -2.40355f
C653 NAND3_4/m1_n2243_n1314# GND -0.4071f
C654 comp[5] GND -1.03412f
C655 NAND3_58/a_n593_982# GND -1.65539f
C656 wl[4] GND 0.36421f
C657 NAND3_58/m1_n3706_n1374# GND -0.40532f
C658 NAND3_58/a_2506_982# GND -2.40355f
C659 NAND3_58/m1_n2243_n1314# GND -0.4071f
C660 comp[6] GND -2.36707f
C661 NAND3_57/a_n593_982# GND -1.65539f
C662 wl[5] GND 0.3642f
C663 NAND3_57/m1_n3706_n1374# GND -0.40532f
C664 NAND3_57/a_2506_982# GND -2.40355f
C665 NAND3_57/m1_n2243_n1314# GND -0.4071f
C666 comp[16] GND -2.08432f
C667 NAND3_47/a_n593_982# GND -1.65539f
C668 wl[15] GND 0.3642f
C669 NAND3_47/m1_n3706_n1374# GND -0.40532f
C670 NAND3_47/a_2506_982# GND -2.40355f
C671 NAND3_47/m1_n2243_n1314# GND -0.4071f
C672 comp[17] GND -1.03412f
C673 NAND3_46/a_n593_982# GND -1.65539f
C674 wl[16] GND 0.36421f
C675 NAND3_46/m1_n3706_n1374# GND -0.40532f
C676 NAND3_46/a_2506_982# GND -2.40355f
C677 NAND3_46/m1_n2243_n1314# GND -0.4071f
C678 comp[27] GND -2.09538f
C679 NAND3_36/a_n593_982# GND -1.65539f
C680 wl[26] GND 0.36421f
C681 NAND3_36/m1_n3706_n1374# GND -0.40532f
C682 NAND3_36/a_2506_982# GND -2.40355f
C683 NAND3_36/m1_n2243_n1314# GND -0.4071f
C684 comp[28] GND -2.08432f
C685 NAND3_35/a_n593_982# GND -1.65539f
C686 wl[27] GND 0.36421f
C687 NAND3_35/m1_n3706_n1374# GND -0.40532f
C688 NAND3_35/a_2506_982# GND -2.40355f
C689 NAND3_35/m1_n2243_n1314# GND -0.4071f
C690 comp[38] GND -1.35996f
C691 NAND3_25/a_n593_982# GND -1.65539f
C692 wl[37] GND 0.3642f
C693 NAND3_25/m1_n3706_n1374# GND -0.40532f
C694 NAND3_25/a_2506_982# GND -2.40355f
C695 NAND3_25/m1_n2243_n1314# GND -0.4071f
C696 comp[39] GND -2.09538f
C697 NAND3_24/a_n593_982# GND -1.65539f
C698 wl[38] GND 0.36421f
C699 NAND3_24/m1_n3706_n1374# GND -0.40532f
C700 NAND3_24/a_2506_982# GND -2.40355f
C701 NAND3_24/m1_n2243_n1314# GND -0.4071f
C702 comp[49] GND -1.70542f
C703 NAND3_14/a_n593_982# GND -1.65539f
C704 wl[48] GND 0.36421f
C705 NAND3_14/m1_n3706_n1374# GND -0.40532f
C706 NAND3_14/a_2506_982# GND -2.40355f
C707 NAND3_14/m1_n2243_n1314# GND -0.4071f
C708 comp[50] GND -1.36228f
C709 NAND3_13/a_n593_982# GND -1.65539f
C710 wl[49] GND 0.3642f
C711 NAND3_13/m1_n3706_n1374# GND -0.40532f
C712 NAND3_13/a_2506_982# GND -2.40355f
C713 NAND3_13/m1_n2243_n1314# GND -0.4071f
C714 comp[60] GND -2.36707f
C715 NAND3_3/a_n593_982# GND -1.65539f
C716 wl[59] GND 0.36421f
C717 NAND3_3/m1_n3706_n1374# GND -0.40532f
C718 NAND3_3/a_2506_982# GND -2.40355f
C719 NAND3_3/m1_n2243_n1314# GND -0.4071f
C720 comp[7] GND -1.70542f
C721 NAND3_56/a_n593_982# GND -1.65539f
C722 wl[6] GND 0.36421f
C723 NAND3_56/m1_n3706_n1374# GND -0.40532f
C724 NAND3_56/a_2506_982# GND -2.40355f
C725 NAND3_56/m1_n2243_n1314# GND -0.4071f
C726 comp[18] GND -2.36707f
C727 NAND3_45/a_n593_982# GND -1.65539f
C728 wl[17] GND 0.3642f
C729 NAND3_45/m1_n3706_n1374# GND -0.40532f
C730 NAND3_45/a_2506_982# GND -2.40355f
C731 NAND3_45/m1_n2243_n1314# GND -0.4071f
C732 comp[29] GND -1.03412f
C733 NAND3_34/a_n593_982# GND -1.65539f
C734 wl[28] GND 0.36421f
C735 NAND3_34/m1_n3706_n1374# GND -0.40532f
C736 NAND3_34/a_2506_982# GND -2.40355f
C737 NAND3_34/m1_n2243_n1314# GND -0.4071f
C738 comp[40] GND -2.08432f
C739 NAND3_23/a_n593_982# GND -1.65539f
C740 wl[39] GND 0.3642f
C741 NAND3_23/m1_n3706_n1374# GND -0.40532f
C742 NAND3_23/a_2506_982# GND -2.40355f
C743 NAND3_23/m1_n2243_n1314# GND -0.4071f
C744 comp[51] GND -2.09538f
C745 NAND3_12/a_n593_982# GND -1.65539f
C746 wl[50] GND 0.36421f
C747 NAND3_12/m1_n3706_n1374# GND -0.40532f
C748 NAND3_12/a_2506_982# GND -2.40355f
C749 NAND3_12/m1_n2243_n1314# GND -0.4071f
C750 comp[61] GND -1.56574f
C751 NAND3_2/a_n593_982# GND -1.65539f
C752 wl[60] GND 0.36421f
C753 NAND3_2/m1_n3706_n1374# GND -0.40532f
C754 NAND3_2/a_2506_982# GND -2.40355f
C755 NAND3_2/m1_n2243_n1314# GND -0.4071f
C756 comp[8] GND -1.36228f
C757 NAND3_55/a_n593_982# GND -1.65539f
C758 wl[7] GND 0.3642f
C759 NAND3_55/m1_n3706_n1374# GND -0.40532f
C760 NAND3_55/a_2506_982# GND -2.40355f
C761 NAND3_55/m1_n2243_n1314# GND -0.4071f
C762 comp[19] GND -1.70542f
C763 NAND3_44/a_n593_982# GND -1.65539f
C764 wl[18] GND 0.36421f
C765 NAND3_44/m1_n3706_n1374# GND -0.40532f
C766 NAND3_44/a_2506_982# GND -2.40355f
C767 NAND3_44/m1_n2243_n1314# GND -0.4071f
C768 comp[30] GND -2.36707f
C769 NAND3_33/a_n593_982# GND -1.65539f
C770 wl[29] GND 0.3642f
C771 NAND3_33/m1_n3706_n1374# GND -0.40532f
C772 NAND3_33/a_2506_982# GND -2.40355f
C773 NAND3_33/m1_n2243_n1314# GND -0.4071f
C774 comp[41] GND -1.03412f
C775 NAND3_22/a_n593_982# GND -1.65539f
C776 wl[40] GND 0.36421f
C777 NAND3_22/m1_n3706_n1374# GND -0.40532f
C778 NAND3_22/a_2506_982# GND -2.40355f
C779 NAND3_22/m1_n2243_n1314# GND -0.4071f
C780 comp[52] GND -2.08432f
C781 NAND3_11/a_n593_982# GND -1.65539f
C782 wl[51] GND 0.3642f
C783 NAND3_11/m1_n3706_n1374# GND -0.40532f
C784 NAND3_11/a_2506_982# GND -2.40355f
C785 NAND3_11/m1_n2243_n1314# GND -0.4071f
C786 comp[62] GND -1.18241f
C787 NAND3_1/a_n593_982# GND -1.65539f
C788 wl[61] GND 0.3642f
C789 NAND3_1/m1_n3706_n1374# GND -0.40532f
C790 NAND3_1/a_2506_982# GND -2.40355f
C791 NAND3_1/m1_n2243_n1314# GND -0.4071f
C792 comp[9] GND -2.09538f
C793 NAND3_54/a_n593_982# GND -1.65539f
C794 wl[8] GND 0.36421f
C795 NAND3_54/m1_n3706_n1374# GND -0.40532f
C796 NAND3_54/a_2506_982# GND -2.40355f
C797 NAND3_54/m1_n2243_n1314# GND -0.4071f
C798 comp[20] GND -1.36228f
C799 NAND3_43/a_n593_982# GND -1.65539f
C800 wl[19] GND 0.3642f
C801 NAND3_43/m1_n3706_n1374# GND -0.40532f
C802 NAND3_43/a_2506_982# GND -2.40355f
C803 NAND3_43/m1_n2243_n1314# GND -0.4071f
C804 comp[31] GND -1.70542f
C805 NAND3_32/a_n593_982# GND -1.65539f
C806 wl[30] GND 0.36421f
C807 NAND3_32/m1_n3706_n1374# GND -0.40532f
C808 NAND3_32/a_2506_982# GND -2.40355f
C809 NAND3_32/m1_n2243_n1314# GND -0.4071f
C810 comp[42] GND -2.36707f
C811 NAND3_21/a_n593_982# GND -1.65539f
C812 wl[41] GND 0.3642f
C813 NAND3_21/m1_n3706_n1374# GND -0.40532f
C814 NAND3_21/a_2506_982# GND -2.40355f
C815 NAND3_21/m1_n2243_n1314# GND -0.4071f
C816 comp[53] GND -1.03412f
C817 NAND3_10/a_n593_982# GND -1.65539f
C818 wl[52] GND 0.3642f
C819 NAND3_10/m1_n3706_n1374# GND -0.40532f
C820 NAND3_10/a_2506_982# GND -2.40355f
C821 NAND3_10/m1_n2243_n1314# GND -0.4071f
C822 NAND3_0/a_n593_982# GND -1.65539f
C823 wl[62] GND 0.36738f
C824 NAND3_0/m1_n3706_n1374# GND -0.40532f
C825 NAND3_0/a_2506_982# GND -2.40355f
C826 NAND3_0/m1_n2243_n1314# GND -0.4071f
C827 comp[10] GND -2.08432f
C828 NAND3_53/a_n593_982# GND -1.65539f
C829 wl[9] GND 0.36421f
C830 NAND3_53/m1_n3706_n1374# GND -0.40532f
C831 NAND3_53/a_2506_982# GND -2.40355f
C832 NAND3_53/m1_n2243_n1314# GND -0.4071f
C833 comp[21] GND -2.09538f
C834 NAND3_42/a_n593_982# GND -1.65539f
C835 wl[20] GND 0.36421f
C836 NAND3_42/m1_n3706_n1374# GND -0.40532f
C837 NAND3_42/a_2506_982# GND -2.40355f
C838 NAND3_42/m1_n2243_n1314# GND -0.4071f
C839 comp[32] GND -1.36228f
C840 NAND3_31/a_n593_982# GND -1.65539f
C841 wl[31] GND 0.3642f
C842 NAND3_31/m1_n3706_n1374# GND -0.40532f
C843 NAND3_31/a_2506_982# GND -2.40355f
C844 NAND3_31/m1_n2243_n1314# GND -0.4071f
C845 comp[43] GND -1.70542f
C846 NAND3_20/a_n593_982# GND -1.65539f
C847 wl[42] GND 0.36421f
C848 NAND3_20/m1_n3706_n1374# GND -0.40532f
C849 NAND3_20/a_2506_982# GND -2.40355f
C850 NAND3_20/m1_n2243_n1314# GND -0.4071f
C851 comp[11] GND -1.0318f
C852 NAND3_52/a_n593_982# GND -1.65539f
C853 wl[10] GND 0.36421f
C854 NAND3_52/m1_n3706_n1374# GND -0.40532f
C855 NAND3_52/a_2506_982# GND -2.40355f
C856 NAND3_52/m1_n2243_n1314# GND -0.4071f
C857 comp[22] GND -2.08432f
C858 NAND3_41/a_n593_982# GND -1.65539f
C859 wl[21] GND 0.3642f
C860 NAND3_41/m1_n3706_n1374# GND -0.40532f
C861 NAND3_41/a_2506_982# GND -2.40355f
C862 NAND3_41/m1_n2243_n1314# GND -0.4071f
C863 comp[33] GND -2.09538f
C864 NAND3_30/a_n593_982# GND -1.65539f
C865 wl[32] GND 0.36421f
C866 NAND3_30/m1_n3706_n1374# GND -0.40532f
C867 NAND3_30/a_2506_982# GND -2.40355f
C868 NAND3_30/m1_n2243_n1314# GND -0.4071f
C869 comp[1] GND -1.53862f
C870 m1_n4168_2156# GND -1.88461f
C871 NAND3_62/a_n593_982# GND -1.65849f
C872 wl[0] GND 0.36572f
C873 NAND3_62/m1_n3706_n1374# GND -0.43108f
C874 NAND3_62/a_2506_982# GND -2.40544f
C875 NAND3_62/m1_n2243_n1314# GND -0.43199f
C876 VDD GND -0.29035p
C877 comp[12] GND -2.36475f
C878 NAND3_51/a_n593_982# GND -1.65539f
C879 wl[11] GND 0.3642f
C880 NAND3_51/m1_n3706_n1374# GND -0.40532f
C881 NAND3_51/a_2506_982# GND -2.40355f
C882 NAND3_51/m1_n2243_n1314# GND -0.4071f
C883 comp[23] GND -1.03412f
C884 NAND3_40/a_n593_982# GND -1.65539f
C885 wl[22] GND 0.36421f
C886 NAND3_40/m1_n3706_n1374# GND -0.40532f
C887 NAND3_40/a_2506_982# GND -2.40355f
C888 NAND3_40/m1_n2243_n1314# GND -0.4071f
C889 comp[2] GND -1.36228f
C890 NAND3_61/a_n593_982# GND -1.65539f
C891 wl[1] GND 0.3642f
C892 NAND3_61/m1_n3706_n1374# GND -0.40532f
C893 NAND3_61/a_2506_982# GND -2.40355f
C894 NAND3_61/m1_n2243_n1314# GND -0.4071f
C895 comp[13] GND -1.70542f
C896 NAND3_50/a_n593_982# GND -1.65539f
C897 wl[12] GND 0.36421f
C898 NAND3_50/m1_n3706_n1374# GND -0.40532f
C899 NAND3_50/a_2506_982# GND -2.40355f
C900 NAND3_50/m1_n2243_n1314# GND -0.4071f
C901 comp[3] GND -2.09538f
C902 NAND3_60/a_n593_982# GND -1.65539f
C903 wl[2] GND 0.36421f
C904 NAND3_60/m1_n3706_n1374# GND -0.40532f
C905 NAND3_60/a_2506_982# GND -2.40355f
C906 NAND3_60/m1_n2243_n1314# GND -0.4071f
.ends
