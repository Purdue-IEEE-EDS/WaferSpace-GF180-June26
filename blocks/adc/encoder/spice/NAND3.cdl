** sch_path: /foss/designs/encoder/sym/NAND3.sch
.subckt NAND3 B A VDD out C GND
M5 out net1 VDD VDD pfet_03v3 L=0.28u W=16.5u
M6 out net1 GND GND nfet_03v3 L=0.28u W=10.16u
M7 cbar C VDD VDD pfet_03v3 L=0.28u W=16.5u
M8 cbar C GND GND nfet_03v3 L=0.28u W=10.16u
M13 net1 A VDD VDD pfet_03v3 L=0.28u W=16.5u
M14 net1 B VDD VDD pfet_03v3 L=0.28u W=16.5u
M15 net1 cbar VDD VDD pfet_03v3 L=0.28u W=16.5u
M16 net1 A net2 GND nfet_03v3 L=0.28u W=10.16u
M17 net2 B net3 GND nfet_03v3 L=0.28u W=10.16u
M18 net3 cbar GND GND nfet_03v3 L=0.28u W=10.16u
.ends
