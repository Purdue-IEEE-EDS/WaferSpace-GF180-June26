* Extracted by KLayout with GF180MCU LVS runset on : 04/06/2026 18:27

.SUBCKT dff_encoder GND Q D CLK RST VDD
M$1 Q \$8 VDD VDD pfet_03v3 L=0.28U W=1.76U AS=1.144P AD=1.144P PS=4.82U
+ PD=4.82U
M$2 \$15 D VDD VDD pfet_03v3 L=0.28U W=0.88U AS=0.572P AD=0.3696P PS=3.06U
+ PD=1.72U
M$3 \$4 CLK \$15 VDD pfet_03v3 L=0.28U W=0.88U AS=0.3696P AD=0.572P PS=1.72U
+ PD=3.06U
M$4 \$16 CLK VDD VDD pfet_03v3 L=0.28U W=0.88U AS=0.572P AD=0.3696P PS=3.06U
+ PD=1.72U
M$5 \$6 \$4 \$16 VDD pfet_03v3 L=0.28U W=0.88U AS=0.3696P AD=0.572P PS=1.72U
+ PD=3.06U
M$6 VDD RST \$6 VDD pfet_03v3 L=0.28U W=0.88U AS=0.572P AD=0.3696P PS=3.06U
+ PD=1.72U
M$7 \$8 \$6 VDD VDD pfet_03v3 L=0.28U W=0.88U AS=0.3696P AD=0.572P PS=1.72U
+ PD=3.06U
M$8 GND D \$4 GND nfet_03v3 L=0.28U W=0.36U AS=0.228P AD=0.1482P PS=1.98U
+ PD=1.18U
M$9 \$5 CLK GND GND nfet_03v3 L=0.28U W=0.36U AS=0.1482P AD=0.1482P PS=1.18U
+ PD=1.18U
M$10 \$6 \$4 \$5 GND nfet_03v3 L=0.28U W=0.36U AS=0.1482P AD=0.228P PS=1.18U
+ PD=1.98U
M$11 \$7 \$6 GND GND nfet_03v3 L=0.28U W=0.36U AS=0.228P AD=0.1482P PS=1.98U
+ PD=1.18U
M$12 \$8 CLK \$7 GND nfet_03v3 L=0.28U W=0.36U AS=0.1482P AD=0.228P PS=1.18U
+ PD=1.98U
M$13 Q \$8 GND GND nfet_03v3 L=0.28U W=0.88U AS=0.5368P AD=0.5368P PS=2.98U
+ PD=2.98U
.ENDS dff_encoder
