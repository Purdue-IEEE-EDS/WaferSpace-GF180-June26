* Extracted by KLayout with GF180MCU LVS runset on : 15/06/2026 21:16

.SUBCKT dff_encoder GND CLK Q VDD
M$1 \$18 CLK \$6 VDD pfet_03v3 L=0.28U W=0.88U AS=0.572P AD=0.572P PS=3.06U
+ PD=3.06U
M$2 \$19 CLK VDD VDD pfet_03v3 L=0.28U W=0.88U AS=0.572P AD=0.572P PS=3.06U
+ PD=3.06U
M$3 \$18 \$7 VDD VDD pfet_03v3 L=0.28U W=0.88U AS=0.572P AD=0.572P PS=3.06U
+ PD=3.06U
M$4 \$8 \$6 \$19 VDD pfet_03v3 L=0.28U W=0.88U AS=0.572P AD=0.572P PS=3.06U
+ PD=3.06U
M$5 VDD \$15 \$8 VDD pfet_03v3 L=0.28U W=0.88U AS=0.572P AD=0.3696P PS=3.06U
+ PD=1.72U
M$6 \$2 \$8 VDD VDD pfet_03v3 L=0.28U W=0.88U AS=0.3696P AD=0.572P PS=1.72U
+ PD=3.06U
M$7 VDD \$2 Q VDD pfet_03v3 L=0.28U W=1.76U AS=1.144P AD=1.144P PS=4.82U
+ PD=4.82U
M$8 \$3 CLK GND GND nfet_03v3 L=0.28U W=0.36U AS=0.228P AD=0.228P PS=1.98U
+ PD=1.98U
M$9 \$4 CLK \$2 GND nfet_03v3 L=0.28U W=0.36U AS=0.228P AD=0.228P PS=1.98U
+ PD=1.98U
M$10 GND \$7 \$6 GND nfet_03v3 L=0.28U W=0.36U AS=0.228P AD=0.228P PS=1.98U
+ PD=1.98U
M$11 \$8 \$6 \$3 GND nfet_03v3 L=0.28U W=0.36U AS=0.228P AD=0.228P PS=1.98U
+ PD=1.98U
M$12 GND \$8 \$4 GND nfet_03v3 L=0.28U W=0.36U AS=0.228P AD=0.228P PS=1.98U
+ PD=1.98U
M$13 GND \$2 Q GND nfet_03v3 L=0.28U W=0.88U AS=0.5368P AD=0.5368P PS=2.98U
+ PD=2.98U
.ENDS dff_encoder
