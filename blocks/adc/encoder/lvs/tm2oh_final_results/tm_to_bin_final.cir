* Extracted by KLayout with GF180MCU LVS runset on : 19/06/2026 17:51

.SUBCKT tm_to_bin2 GND out|wl[0] B|comp[1] VDD B|comp[0] out|wl[1] B|comp[2]
+ out|wl[2] B|comp[3] out|wl[3] B|comp[4] out|wl[4] B|comp[5] out|wl[5]
+ B|comp[6] out|wl[6] B|comp[7] out|wl[7] B|comp[8] out|wl[8] B|comp[9]
+ out|wl[9] B|comp[10] out|wl[10] B|comp[11] out|wl[11] B|comp[12] out|wl[12]
+ B|comp[13] out|wl[13] B|comp[14] out|wl[14] B|comp[15] out|wl[15] B|comp[16]
+ out|wl[16] B|comp[17] out|wl[17] B|comp[18] out|wl[18] B|comp[19] out|wl[19]
+ B|comp[20] out|wl[20] B|comp[21] out|wl[21] B|comp[22] out|wl[22] B|comp[23]
+ out|wl[23] B|comp[24] out|wl[24] B|comp[25] out|wl[25] B|comp[26] out|wl[26]
+ B|comp[27] out|wl[27] B|comp[28] out|wl[28] B|comp[29] out|wl[29] B|comp[30]
+ out|wl[30] B|comp[31] out|wl[31] B|comp[32] out|wl[32] B|comp[33] out|wl[33]
+ B|comp[34] out|wl[34] B|comp[35] out|wl[35] B|comp[36] out|wl[36] B|comp[37]
+ out|wl[37] B|comp[38] out|wl[38] B|comp[39] out|wl[39] B|comp[40] out|wl[40]
+ B|comp[41] out|wl[41] B|comp[42] out|wl[42] B|comp[43] out|wl[43] B|comp[44]
+ out|wl[44] B|comp[45] out|wl[45] B|comp[46] out|wl[46] B|comp[47] out|wl[47]
+ B|comp[48] out|wl[48] B|comp[49] out|wl[49] B|comp[50] out|wl[50] B|comp[51]
+ out|wl[51] B|comp[52] out|wl[52] B|comp[53] out|wl[53] B|comp[54] out|wl[54]
+ B|comp[55] out|wl[55] B|comp[56] out|wl[56] B|comp[57] out|wl[57] B|comp[58]
+ out|wl[58] B|comp[59] out|wl[59] B|comp[60] out|wl[60] B|comp[61] out|wl[61]
+ B|comp[62] out|wl[62]
M$1 \$2 B|comp[1] VDD VDD pfet_03v3 L=0.28U W=2U AS=1.3P AD=1.3P PS=5.3U PD=5.3U
M$2 \$3 VDD VDD VDD pfet_03v3 L=0.28U W=2U AS=1.3P AD=0.84P PS=5.3U PD=2.84U
M$3 VDD B|comp[0] \$3 VDD pfet_03v3 L=0.28U W=2U AS=0.84P AD=0.84P PS=2.84U
+ PD=2.84U
M$4 \$3 \$2 VDD VDD pfet_03v3 L=0.28U W=2U AS=0.84P AD=1.3P PS=2.84U PD=5.3U
M$5 VDD \$3 out|wl[0] VDD pfet_03v3 L=0.28U W=2U AS=1.3P AD=1.3P PS=5.3U PD=5.3U
M$6 \$18 B|comp[2] VDD VDD pfet_03v3 L=0.28U W=2U AS=1.3P AD=1.3P PS=5.3U
+ PD=5.3U
M$7 \$19 B|comp[0] VDD VDD pfet_03v3 L=0.28U W=2U AS=1.3P AD=0.84P PS=5.3U
+ PD=2.84U
M$8 VDD B|comp[1] \$19 VDD pfet_03v3 L=0.28U W=2U AS=0.84P AD=0.84P PS=2.84U
+ PD=2.84U
M$9 \$19 \$18 VDD VDD pfet_03v3 L=0.28U W=2U AS=0.84P AD=1.3P PS=2.84U PD=5.3U
M$10 VDD \$19 out|wl[1] VDD pfet_03v3 L=0.28U W=2U AS=1.3P AD=1.3P PS=5.3U
+ PD=5.3U
M$11 \$31 B|comp[3] VDD VDD pfet_03v3 L=0.28U W=2U AS=1.3P AD=1.3P PS=5.3U
+ PD=5.3U
M$12 \$32 B|comp[1] VDD VDD pfet_03v3 L=0.28U W=2U AS=1.3P AD=0.84P PS=5.3U
+ PD=2.84U
M$13 VDD B|comp[2] \$32 VDD pfet_03v3 L=0.28U W=2U AS=0.84P AD=0.84P PS=2.84U
+ PD=2.84U
M$14 \$32 \$31 VDD VDD pfet_03v3 L=0.28U W=2U AS=0.84P AD=1.3P PS=2.84U PD=5.3U
M$15 VDD \$32 out|wl[2] VDD pfet_03v3 L=0.28U W=2U AS=1.3P AD=1.3P PS=5.3U
+ PD=5.3U
M$16 \$44 B|comp[4] VDD VDD pfet_03v3 L=0.28U W=2U AS=1.3P AD=1.3P PS=5.3U
+ PD=5.3U
M$17 \$45 B|comp[2] VDD VDD pfet_03v3 L=0.28U W=2U AS=1.3P AD=0.84P PS=5.3U
+ PD=2.84U
M$18 VDD B|comp[3] \$45 VDD pfet_03v3 L=0.28U W=2U AS=0.84P AD=0.84P PS=2.84U
+ PD=2.84U
M$19 \$45 \$44 VDD VDD pfet_03v3 L=0.28U W=2U AS=0.84P AD=1.3P PS=2.84U PD=5.3U
M$20 VDD \$45 out|wl[3] VDD pfet_03v3 L=0.28U W=2U AS=1.3P AD=1.3P PS=5.3U
+ PD=5.3U
M$21 \$57 B|comp[5] VDD VDD pfet_03v3 L=0.28U W=2U AS=1.3P AD=1.3P PS=5.3U
+ PD=5.3U
M$22 \$58 B|comp[3] VDD VDD pfet_03v3 L=0.28U W=2U AS=1.3P AD=0.84P PS=5.3U
+ PD=2.84U
M$23 VDD B|comp[4] \$58 VDD pfet_03v3 L=0.28U W=2U AS=0.84P AD=0.84P PS=2.84U
+ PD=2.84U
M$24 \$58 \$57 VDD VDD pfet_03v3 L=0.28U W=2U AS=0.84P AD=1.3P PS=2.84U PD=5.3U
M$25 VDD \$58 out|wl[4] VDD pfet_03v3 L=0.28U W=2U AS=1.3P AD=1.3P PS=5.3U
+ PD=5.3U
M$26 \$70 B|comp[6] VDD VDD pfet_03v3 L=0.28U W=2U AS=1.3P AD=1.3P PS=5.3U
+ PD=5.3U
M$27 \$71 B|comp[4] VDD VDD pfet_03v3 L=0.28U W=2U AS=1.3P AD=0.84P PS=5.3U
+ PD=2.84U
M$28 VDD B|comp[5] \$71 VDD pfet_03v3 L=0.28U W=2U AS=0.84P AD=0.84P PS=2.84U
+ PD=2.84U
M$29 \$71 \$70 VDD VDD pfet_03v3 L=0.28U W=2U AS=0.84P AD=1.3P PS=2.84U PD=5.3U
M$30 VDD \$71 out|wl[5] VDD pfet_03v3 L=0.28U W=2U AS=1.3P AD=1.3P PS=5.3U
+ PD=5.3U
M$31 \$83 B|comp[7] VDD VDD pfet_03v3 L=0.28U W=2U AS=1.3P AD=1.3P PS=5.3U
+ PD=5.3U
M$32 \$84 B|comp[5] VDD VDD pfet_03v3 L=0.28U W=2U AS=1.3P AD=0.84P PS=5.3U
+ PD=2.84U
M$33 VDD B|comp[6] \$84 VDD pfet_03v3 L=0.28U W=2U AS=0.84P AD=0.84P PS=2.84U
+ PD=2.84U
M$34 \$84 \$83 VDD VDD pfet_03v3 L=0.28U W=2U AS=0.84P AD=1.3P PS=2.84U PD=5.3U
M$35 VDD \$84 out|wl[6] VDD pfet_03v3 L=0.28U W=2U AS=1.3P AD=1.3P PS=5.3U
+ PD=5.3U
M$36 \$96 B|comp[8] VDD VDD pfet_03v3 L=0.28U W=2U AS=1.3P AD=1.3P PS=5.3U
+ PD=5.3U
M$37 \$97 B|comp[6] VDD VDD pfet_03v3 L=0.28U W=2U AS=1.3P AD=0.84P PS=5.3U
+ PD=2.84U
M$38 VDD B|comp[7] \$97 VDD pfet_03v3 L=0.28U W=2U AS=0.84P AD=0.84P PS=2.84U
+ PD=2.84U
M$39 \$97 \$96 VDD VDD pfet_03v3 L=0.28U W=2U AS=0.84P AD=1.3P PS=2.84U PD=5.3U
M$40 VDD \$97 out|wl[7] VDD pfet_03v3 L=0.28U W=2U AS=1.3P AD=1.3P PS=5.3U
+ PD=5.3U
M$41 \$109 B|comp[9] VDD VDD pfet_03v3 L=0.28U W=2U AS=1.3P AD=1.3P PS=5.3U
+ PD=5.3U
M$42 \$110 B|comp[7] VDD VDD pfet_03v3 L=0.28U W=2U AS=1.3P AD=0.84P PS=5.3U
+ PD=2.84U
M$43 VDD B|comp[8] \$110 VDD pfet_03v3 L=0.28U W=2U AS=0.84P AD=0.84P PS=2.84U
+ PD=2.84U
M$44 \$110 \$109 VDD VDD pfet_03v3 L=0.28U W=2U AS=0.84P AD=1.3P PS=2.84U
+ PD=5.3U
M$45 VDD \$110 out|wl[8] VDD pfet_03v3 L=0.28U W=2U AS=1.3P AD=1.3P PS=5.3U
+ PD=5.3U
M$46 \$122 B|comp[10] VDD VDD pfet_03v3 L=0.28U W=2U AS=1.3P AD=1.3P PS=5.3U
+ PD=5.3U
M$47 \$123 B|comp[8] VDD VDD pfet_03v3 L=0.28U W=2U AS=1.3P AD=0.84P PS=5.3U
+ PD=2.84U
M$48 VDD B|comp[9] \$123 VDD pfet_03v3 L=0.28U W=2U AS=0.84P AD=0.84P PS=2.84U
+ PD=2.84U
M$49 \$123 \$122 VDD VDD pfet_03v3 L=0.28U W=2U AS=0.84P AD=1.3P PS=2.84U
+ PD=5.3U
M$50 VDD \$123 out|wl[9] VDD pfet_03v3 L=0.28U W=2U AS=1.3P AD=1.3P PS=5.3U
+ PD=5.3U
M$51 \$135 B|comp[11] VDD VDD pfet_03v3 L=0.28U W=2U AS=1.3P AD=1.3P PS=5.3U
+ PD=5.3U
M$52 \$136 B|comp[9] VDD VDD pfet_03v3 L=0.28U W=2U AS=1.3P AD=0.84P PS=5.3U
+ PD=2.84U
M$53 VDD B|comp[10] \$136 VDD pfet_03v3 L=0.28U W=2U AS=0.84P AD=0.84P PS=2.84U
+ PD=2.84U
M$54 \$136 \$135 VDD VDD pfet_03v3 L=0.28U W=2U AS=0.84P AD=1.3P PS=2.84U
+ PD=5.3U
M$55 VDD \$136 out|wl[10] VDD pfet_03v3 L=0.28U W=2U AS=1.3P AD=1.3P PS=5.3U
+ PD=5.3U
M$56 \$148 B|comp[12] VDD VDD pfet_03v3 L=0.28U W=2U AS=1.3P AD=1.3P PS=5.3U
+ PD=5.3U
M$57 \$149 B|comp[10] VDD VDD pfet_03v3 L=0.28U W=2U AS=1.3P AD=0.84P PS=5.3U
+ PD=2.84U
M$58 VDD B|comp[11] \$149 VDD pfet_03v3 L=0.28U W=2U AS=0.84P AD=0.84P PS=2.84U
+ PD=2.84U
M$59 \$149 \$148 VDD VDD pfet_03v3 L=0.28U W=2U AS=0.84P AD=1.3P PS=2.84U
+ PD=5.3U
M$60 VDD \$149 out|wl[11] VDD pfet_03v3 L=0.28U W=2U AS=1.3P AD=1.3P PS=5.3U
+ PD=5.3U
M$61 \$161 B|comp[13] VDD VDD pfet_03v3 L=0.28U W=2U AS=1.3P AD=1.3P PS=5.3U
+ PD=5.3U
M$62 \$162 B|comp[11] VDD VDD pfet_03v3 L=0.28U W=2U AS=1.3P AD=0.84P PS=5.3U
+ PD=2.84U
M$63 VDD B|comp[12] \$162 VDD pfet_03v3 L=0.28U W=2U AS=0.84P AD=0.84P PS=2.84U
+ PD=2.84U
M$64 \$162 \$161 VDD VDD pfet_03v3 L=0.28U W=2U AS=0.84P AD=1.3P PS=2.84U
+ PD=5.3U
M$65 VDD \$162 out|wl[12] VDD pfet_03v3 L=0.28U W=2U AS=1.3P AD=1.3P PS=5.3U
+ PD=5.3U
M$66 \$174 B|comp[14] VDD VDD pfet_03v3 L=0.28U W=2U AS=1.3P AD=1.3P PS=5.3U
+ PD=5.3U
M$67 \$175 B|comp[12] VDD VDD pfet_03v3 L=0.28U W=2U AS=1.3P AD=0.84P PS=5.3U
+ PD=2.84U
M$68 VDD B|comp[13] \$175 VDD pfet_03v3 L=0.28U W=2U AS=0.84P AD=0.84P PS=2.84U
+ PD=2.84U
M$69 \$175 \$174 VDD VDD pfet_03v3 L=0.28U W=2U AS=0.84P AD=1.3P PS=2.84U
+ PD=5.3U
M$70 VDD \$175 out|wl[13] VDD pfet_03v3 L=0.28U W=2U AS=1.3P AD=1.3P PS=5.3U
+ PD=5.3U
M$71 \$187 B|comp[15] VDD VDD pfet_03v3 L=0.28U W=2U AS=1.3P AD=1.3P PS=5.3U
+ PD=5.3U
M$72 \$188 B|comp[13] VDD VDD pfet_03v3 L=0.28U W=2U AS=1.3P AD=0.84P PS=5.3U
+ PD=2.84U
M$73 VDD B|comp[14] \$188 VDD pfet_03v3 L=0.28U W=2U AS=0.84P AD=0.84P PS=2.84U
+ PD=2.84U
M$74 \$188 \$187 VDD VDD pfet_03v3 L=0.28U W=2U AS=0.84P AD=1.3P PS=2.84U
+ PD=5.3U
M$75 VDD \$188 out|wl[14] VDD pfet_03v3 L=0.28U W=2U AS=1.3P AD=1.3P PS=5.3U
+ PD=5.3U
M$76 \$200 B|comp[16] VDD VDD pfet_03v3 L=0.28U W=2U AS=1.3P AD=1.3P PS=5.3U
+ PD=5.3U
M$77 \$201 B|comp[14] VDD VDD pfet_03v3 L=0.28U W=2U AS=1.3P AD=0.84P PS=5.3U
+ PD=2.84U
M$78 VDD B|comp[15] \$201 VDD pfet_03v3 L=0.28U W=2U AS=0.84P AD=0.84P PS=2.84U
+ PD=2.84U
M$79 \$201 \$200 VDD VDD pfet_03v3 L=0.28U W=2U AS=0.84P AD=1.3P PS=2.84U
+ PD=5.3U
M$80 VDD \$201 out|wl[15] VDD pfet_03v3 L=0.28U W=2U AS=1.3P AD=1.3P PS=5.3U
+ PD=5.3U
M$81 \$213 B|comp[17] VDD VDD pfet_03v3 L=0.28U W=2U AS=1.3P AD=1.3P PS=5.3U
+ PD=5.3U
M$82 \$214 B|comp[15] VDD VDD pfet_03v3 L=0.28U W=2U AS=1.3P AD=0.84P PS=5.3U
+ PD=2.84U
M$83 VDD B|comp[16] \$214 VDD pfet_03v3 L=0.28U W=2U AS=0.84P AD=0.84P PS=2.84U
+ PD=2.84U
M$84 \$214 \$213 VDD VDD pfet_03v3 L=0.28U W=2U AS=0.84P AD=1.3P PS=2.84U
+ PD=5.3U
M$85 VDD \$214 out|wl[16] VDD pfet_03v3 L=0.28U W=2U AS=1.3P AD=1.3P PS=5.3U
+ PD=5.3U
M$86 \$226 B|comp[18] VDD VDD pfet_03v3 L=0.28U W=2U AS=1.3P AD=1.3P PS=5.3U
+ PD=5.3U
M$87 \$227 B|comp[16] VDD VDD pfet_03v3 L=0.28U W=2U AS=1.3P AD=0.84P PS=5.3U
+ PD=2.84U
M$88 VDD B|comp[17] \$227 VDD pfet_03v3 L=0.28U W=2U AS=0.84P AD=0.84P PS=2.84U
+ PD=2.84U
M$89 \$227 \$226 VDD VDD pfet_03v3 L=0.28U W=2U AS=0.84P AD=1.3P PS=2.84U
+ PD=5.3U
M$90 VDD \$227 out|wl[17] VDD pfet_03v3 L=0.28U W=2U AS=1.3P AD=1.3P PS=5.3U
+ PD=5.3U
M$91 \$239 B|comp[19] VDD VDD pfet_03v3 L=0.28U W=2U AS=1.3P AD=1.3P PS=5.3U
+ PD=5.3U
M$92 \$240 B|comp[17] VDD VDD pfet_03v3 L=0.28U W=2U AS=1.3P AD=0.84P PS=5.3U
+ PD=2.84U
M$93 VDD B|comp[18] \$240 VDD pfet_03v3 L=0.28U W=2U AS=0.84P AD=0.84P PS=2.84U
+ PD=2.84U
M$94 \$240 \$239 VDD VDD pfet_03v3 L=0.28U W=2U AS=0.84P AD=1.3P PS=2.84U
+ PD=5.3U
M$95 VDD \$240 out|wl[18] VDD pfet_03v3 L=0.28U W=2U AS=1.3P AD=1.3P PS=5.3U
+ PD=5.3U
M$96 \$252 B|comp[20] VDD VDD pfet_03v3 L=0.28U W=2U AS=1.3P AD=1.3P PS=5.3U
+ PD=5.3U
M$97 \$253 B|comp[18] VDD VDD pfet_03v3 L=0.28U W=2U AS=1.3P AD=0.84P PS=5.3U
+ PD=2.84U
M$98 VDD B|comp[19] \$253 VDD pfet_03v3 L=0.28U W=2U AS=0.84P AD=0.84P PS=2.84U
+ PD=2.84U
M$99 \$253 \$252 VDD VDD pfet_03v3 L=0.28U W=2U AS=0.84P AD=1.3P PS=2.84U
+ PD=5.3U
M$100 VDD \$253 out|wl[19] VDD pfet_03v3 L=0.28U W=2U AS=1.3P AD=1.3P PS=5.3U
+ PD=5.3U
M$101 \$265 B|comp[21] VDD VDD pfet_03v3 L=0.28U W=2U AS=1.3P AD=1.3P PS=5.3U
+ PD=5.3U
M$102 \$266 B|comp[19] VDD VDD pfet_03v3 L=0.28U W=2U AS=1.3P AD=0.84P PS=5.3U
+ PD=2.84U
M$103 VDD B|comp[20] \$266 VDD pfet_03v3 L=0.28U W=2U AS=0.84P AD=0.84P
+ PS=2.84U PD=2.84U
M$104 \$266 \$265 VDD VDD pfet_03v3 L=0.28U W=2U AS=0.84P AD=1.3P PS=2.84U
+ PD=5.3U
M$105 VDD \$266 out|wl[20] VDD pfet_03v3 L=0.28U W=2U AS=1.3P AD=1.3P PS=5.3U
+ PD=5.3U
M$106 \$278 B|comp[22] VDD VDD pfet_03v3 L=0.28U W=2U AS=1.3P AD=1.3P PS=5.3U
+ PD=5.3U
M$107 \$279 B|comp[20] VDD VDD pfet_03v3 L=0.28U W=2U AS=1.3P AD=0.84P PS=5.3U
+ PD=2.84U
M$108 VDD B|comp[21] \$279 VDD pfet_03v3 L=0.28U W=2U AS=0.84P AD=0.84P
+ PS=2.84U PD=2.84U
M$109 \$279 \$278 VDD VDD pfet_03v3 L=0.28U W=2U AS=0.84P AD=1.3P PS=2.84U
+ PD=5.3U
M$110 VDD \$279 out|wl[21] VDD pfet_03v3 L=0.28U W=2U AS=1.3P AD=1.3P PS=5.3U
+ PD=5.3U
M$111 \$291 B|comp[23] VDD VDD pfet_03v3 L=0.28U W=2U AS=1.3P AD=1.3P PS=5.3U
+ PD=5.3U
M$112 \$292 B|comp[21] VDD VDD pfet_03v3 L=0.28U W=2U AS=1.3P AD=0.84P PS=5.3U
+ PD=2.84U
M$113 VDD B|comp[22] \$292 VDD pfet_03v3 L=0.28U W=2U AS=0.84P AD=0.84P
+ PS=2.84U PD=2.84U
M$114 \$292 \$291 VDD VDD pfet_03v3 L=0.28U W=2U AS=0.84P AD=1.3P PS=2.84U
+ PD=5.3U
M$115 VDD \$292 out|wl[22] VDD pfet_03v3 L=0.28U W=2U AS=1.3P AD=1.3P PS=5.3U
+ PD=5.3U
M$116 \$304 B|comp[24] VDD VDD pfet_03v3 L=0.28U W=2U AS=1.3P AD=1.3P PS=5.3U
+ PD=5.3U
M$117 \$305 B|comp[22] VDD VDD pfet_03v3 L=0.28U W=2U AS=1.3P AD=0.84P PS=5.3U
+ PD=2.84U
M$118 VDD B|comp[23] \$305 VDD pfet_03v3 L=0.28U W=2U AS=0.84P AD=0.84P
+ PS=2.84U PD=2.84U
M$119 \$305 \$304 VDD VDD pfet_03v3 L=0.28U W=2U AS=0.84P AD=1.3P PS=2.84U
+ PD=5.3U
M$120 VDD \$305 out|wl[23] VDD pfet_03v3 L=0.28U W=2U AS=1.3P AD=1.3P PS=5.3U
+ PD=5.3U
M$121 \$317 B|comp[25] VDD VDD pfet_03v3 L=0.28U W=2U AS=1.3P AD=1.3P PS=5.3U
+ PD=5.3U
M$122 \$318 B|comp[23] VDD VDD pfet_03v3 L=0.28U W=2U AS=1.3P AD=0.84P PS=5.3U
+ PD=2.84U
M$123 VDD B|comp[24] \$318 VDD pfet_03v3 L=0.28U W=2U AS=0.84P AD=0.84P
+ PS=2.84U PD=2.84U
M$124 \$318 \$317 VDD VDD pfet_03v3 L=0.28U W=2U AS=0.84P AD=1.3P PS=2.84U
+ PD=5.3U
M$125 VDD \$318 out|wl[24] VDD pfet_03v3 L=0.28U W=2U AS=1.3P AD=1.3P PS=5.3U
+ PD=5.3U
M$126 \$330 B|comp[26] VDD VDD pfet_03v3 L=0.28U W=2U AS=1.3P AD=1.3P PS=5.3U
+ PD=5.3U
M$127 \$331 B|comp[24] VDD VDD pfet_03v3 L=0.28U W=2U AS=1.3P AD=0.84P PS=5.3U
+ PD=2.84U
M$128 VDD B|comp[25] \$331 VDD pfet_03v3 L=0.28U W=2U AS=0.84P AD=0.84P
+ PS=2.84U PD=2.84U
M$129 \$331 \$330 VDD VDD pfet_03v3 L=0.28U W=2U AS=0.84P AD=1.3P PS=2.84U
+ PD=5.3U
M$130 VDD \$331 out|wl[25] VDD pfet_03v3 L=0.28U W=2U AS=1.3P AD=1.3P PS=5.3U
+ PD=5.3U
M$131 \$343 B|comp[27] VDD VDD pfet_03v3 L=0.28U W=2U AS=1.3P AD=1.3P PS=5.3U
+ PD=5.3U
M$132 \$344 B|comp[25] VDD VDD pfet_03v3 L=0.28U W=2U AS=1.3P AD=0.84P PS=5.3U
+ PD=2.84U
M$133 VDD B|comp[26] \$344 VDD pfet_03v3 L=0.28U W=2U AS=0.84P AD=0.84P
+ PS=2.84U PD=2.84U
M$134 \$344 \$343 VDD VDD pfet_03v3 L=0.28U W=2U AS=0.84P AD=1.3P PS=2.84U
+ PD=5.3U
M$135 VDD \$344 out|wl[26] VDD pfet_03v3 L=0.28U W=2U AS=1.3P AD=1.3P PS=5.3U
+ PD=5.3U
M$136 \$356 B|comp[28] VDD VDD pfet_03v3 L=0.28U W=2U AS=1.3P AD=1.3P PS=5.3U
+ PD=5.3U
M$137 \$357 B|comp[26] VDD VDD pfet_03v3 L=0.28U W=2U AS=1.3P AD=0.84P PS=5.3U
+ PD=2.84U
M$138 VDD B|comp[27] \$357 VDD pfet_03v3 L=0.28U W=2U AS=0.84P AD=0.84P
+ PS=2.84U PD=2.84U
M$139 \$357 \$356 VDD VDD pfet_03v3 L=0.28U W=2U AS=0.84P AD=1.3P PS=2.84U
+ PD=5.3U
M$140 VDD \$357 out|wl[27] VDD pfet_03v3 L=0.28U W=2U AS=1.3P AD=1.3P PS=5.3U
+ PD=5.3U
M$141 \$369 B|comp[29] VDD VDD pfet_03v3 L=0.28U W=2U AS=1.3P AD=1.3P PS=5.3U
+ PD=5.3U
M$142 \$370 B|comp[27] VDD VDD pfet_03v3 L=0.28U W=2U AS=1.3P AD=0.84P PS=5.3U
+ PD=2.84U
M$143 VDD B|comp[28] \$370 VDD pfet_03v3 L=0.28U W=2U AS=0.84P AD=0.84P
+ PS=2.84U PD=2.84U
M$144 \$370 \$369 VDD VDD pfet_03v3 L=0.28U W=2U AS=0.84P AD=1.3P PS=2.84U
+ PD=5.3U
M$145 VDD \$370 out|wl[28] VDD pfet_03v3 L=0.28U W=2U AS=1.3P AD=1.3P PS=5.3U
+ PD=5.3U
M$146 \$382 B|comp[30] VDD VDD pfet_03v3 L=0.28U W=2U AS=1.3P AD=1.3P PS=5.3U
+ PD=5.3U
M$147 \$383 B|comp[28] VDD VDD pfet_03v3 L=0.28U W=2U AS=1.3P AD=0.84P PS=5.3U
+ PD=2.84U
M$148 VDD B|comp[29] \$383 VDD pfet_03v3 L=0.28U W=2U AS=0.84P AD=0.84P
+ PS=2.84U PD=2.84U
M$149 \$383 \$382 VDD VDD pfet_03v3 L=0.28U W=2U AS=0.84P AD=1.3P PS=2.84U
+ PD=5.3U
M$150 VDD \$383 out|wl[29] VDD pfet_03v3 L=0.28U W=2U AS=1.3P AD=1.3P PS=5.3U
+ PD=5.3U
M$151 \$395 B|comp[31] VDD VDD pfet_03v3 L=0.28U W=2U AS=1.3P AD=1.3P PS=5.3U
+ PD=5.3U
M$152 \$396 B|comp[29] VDD VDD pfet_03v3 L=0.28U W=2U AS=1.3P AD=0.84P PS=5.3U
+ PD=2.84U
M$153 VDD B|comp[30] \$396 VDD pfet_03v3 L=0.28U W=2U AS=0.84P AD=0.84P
+ PS=2.84U PD=2.84U
M$154 \$396 \$395 VDD VDD pfet_03v3 L=0.28U W=2U AS=0.84P AD=1.3P PS=2.84U
+ PD=5.3U
M$155 VDD \$396 out|wl[30] VDD pfet_03v3 L=0.28U W=2U AS=1.3P AD=1.3P PS=5.3U
+ PD=5.3U
M$156 \$408 B|comp[32] VDD VDD pfet_03v3 L=0.28U W=2U AS=1.3P AD=1.3P PS=5.3U
+ PD=5.3U
M$157 \$409 B|comp[30] VDD VDD pfet_03v3 L=0.28U W=2U AS=1.3P AD=0.84P PS=5.3U
+ PD=2.84U
M$158 VDD B|comp[31] \$409 VDD pfet_03v3 L=0.28U W=2U AS=0.84P AD=0.84P
+ PS=2.84U PD=2.84U
M$159 \$409 \$408 VDD VDD pfet_03v3 L=0.28U W=2U AS=0.84P AD=1.3P PS=2.84U
+ PD=5.3U
M$160 VDD \$409 out|wl[31] VDD pfet_03v3 L=0.28U W=2U AS=1.3P AD=1.3P PS=5.3U
+ PD=5.3U
M$161 \$421 B|comp[33] VDD VDD pfet_03v3 L=0.28U W=2U AS=1.3P AD=1.3P PS=5.3U
+ PD=5.3U
M$162 \$422 B|comp[31] VDD VDD pfet_03v3 L=0.28U W=2U AS=1.3P AD=0.84P PS=5.3U
+ PD=2.84U
M$163 VDD B|comp[32] \$422 VDD pfet_03v3 L=0.28U W=2U AS=0.84P AD=0.84P
+ PS=2.84U PD=2.84U
M$164 \$422 \$421 VDD VDD pfet_03v3 L=0.28U W=2U AS=0.84P AD=1.3P PS=2.84U
+ PD=5.3U
M$165 VDD \$422 out|wl[32] VDD pfet_03v3 L=0.28U W=2U AS=1.3P AD=1.3P PS=5.3U
+ PD=5.3U
M$166 \$434 B|comp[34] VDD VDD pfet_03v3 L=0.28U W=2U AS=1.3P AD=1.3P PS=5.3U
+ PD=5.3U
M$167 \$435 B|comp[32] VDD VDD pfet_03v3 L=0.28U W=2U AS=1.3P AD=0.84P PS=5.3U
+ PD=2.84U
M$168 VDD B|comp[33] \$435 VDD pfet_03v3 L=0.28U W=2U AS=0.84P AD=0.84P
+ PS=2.84U PD=2.84U
M$169 \$435 \$434 VDD VDD pfet_03v3 L=0.28U W=2U AS=0.84P AD=1.3P PS=2.84U
+ PD=5.3U
M$170 VDD \$435 out|wl[33] VDD pfet_03v3 L=0.28U W=2U AS=1.3P AD=1.3P PS=5.3U
+ PD=5.3U
M$171 \$447 B|comp[35] VDD VDD pfet_03v3 L=0.28U W=2U AS=1.3P AD=1.3P PS=5.3U
+ PD=5.3U
M$172 \$448 B|comp[33] VDD VDD pfet_03v3 L=0.28U W=2U AS=1.3P AD=0.84P PS=5.3U
+ PD=2.84U
M$173 VDD B|comp[34] \$448 VDD pfet_03v3 L=0.28U W=2U AS=0.84P AD=0.84P
+ PS=2.84U PD=2.84U
M$174 \$448 \$447 VDD VDD pfet_03v3 L=0.28U W=2U AS=0.84P AD=1.3P PS=2.84U
+ PD=5.3U
M$175 VDD \$448 out|wl[34] VDD pfet_03v3 L=0.28U W=2U AS=1.3P AD=1.3P PS=5.3U
+ PD=5.3U
M$176 \$460 B|comp[36] VDD VDD pfet_03v3 L=0.28U W=2U AS=1.3P AD=1.3P PS=5.3U
+ PD=5.3U
M$177 \$461 B|comp[34] VDD VDD pfet_03v3 L=0.28U W=2U AS=1.3P AD=0.84P PS=5.3U
+ PD=2.84U
M$178 VDD B|comp[35] \$461 VDD pfet_03v3 L=0.28U W=2U AS=0.84P AD=0.84P
+ PS=2.84U PD=2.84U
M$179 \$461 \$460 VDD VDD pfet_03v3 L=0.28U W=2U AS=0.84P AD=1.3P PS=2.84U
+ PD=5.3U
M$180 VDD \$461 out|wl[35] VDD pfet_03v3 L=0.28U W=2U AS=1.3P AD=1.3P PS=5.3U
+ PD=5.3U
M$181 \$473 B|comp[37] VDD VDD pfet_03v3 L=0.28U W=2U AS=1.3P AD=1.3P PS=5.3U
+ PD=5.3U
M$182 \$474 B|comp[35] VDD VDD pfet_03v3 L=0.28U W=2U AS=1.3P AD=0.84P PS=5.3U
+ PD=2.84U
M$183 VDD B|comp[36] \$474 VDD pfet_03v3 L=0.28U W=2U AS=0.84P AD=0.84P
+ PS=2.84U PD=2.84U
M$184 \$474 \$473 VDD VDD pfet_03v3 L=0.28U W=2U AS=0.84P AD=1.3P PS=2.84U
+ PD=5.3U
M$185 VDD \$474 out|wl[36] VDD pfet_03v3 L=0.28U W=2U AS=1.3P AD=1.3P PS=5.3U
+ PD=5.3U
M$186 \$486 B|comp[38] VDD VDD pfet_03v3 L=0.28U W=2U AS=1.3P AD=1.3P PS=5.3U
+ PD=5.3U
M$187 \$487 B|comp[36] VDD VDD pfet_03v3 L=0.28U W=2U AS=1.3P AD=0.84P PS=5.3U
+ PD=2.84U
M$188 VDD B|comp[37] \$487 VDD pfet_03v3 L=0.28U W=2U AS=0.84P AD=0.84P
+ PS=2.84U PD=2.84U
M$189 \$487 \$486 VDD VDD pfet_03v3 L=0.28U W=2U AS=0.84P AD=1.3P PS=2.84U
+ PD=5.3U
M$190 VDD \$487 out|wl[37] VDD pfet_03v3 L=0.28U W=2U AS=1.3P AD=1.3P PS=5.3U
+ PD=5.3U
M$191 \$499 B|comp[39] VDD VDD pfet_03v3 L=0.28U W=2U AS=1.3P AD=1.3P PS=5.3U
+ PD=5.3U
M$192 \$500 B|comp[37] VDD VDD pfet_03v3 L=0.28U W=2U AS=1.3P AD=0.84P PS=5.3U
+ PD=2.84U
M$193 VDD B|comp[38] \$500 VDD pfet_03v3 L=0.28U W=2U AS=0.84P AD=0.84P
+ PS=2.84U PD=2.84U
M$194 \$500 \$499 VDD VDD pfet_03v3 L=0.28U W=2U AS=0.84P AD=1.3P PS=2.84U
+ PD=5.3U
M$195 VDD \$500 out|wl[38] VDD pfet_03v3 L=0.28U W=2U AS=1.3P AD=1.3P PS=5.3U
+ PD=5.3U
M$196 \$512 B|comp[40] VDD VDD pfet_03v3 L=0.28U W=2U AS=1.3P AD=1.3P PS=5.3U
+ PD=5.3U
M$197 \$513 B|comp[38] VDD VDD pfet_03v3 L=0.28U W=2U AS=1.3P AD=0.84P PS=5.3U
+ PD=2.84U
M$198 VDD B|comp[39] \$513 VDD pfet_03v3 L=0.28U W=2U AS=0.84P AD=0.84P
+ PS=2.84U PD=2.84U
M$199 \$513 \$512 VDD VDD pfet_03v3 L=0.28U W=2U AS=0.84P AD=1.3P PS=2.84U
+ PD=5.3U
M$200 VDD \$513 out|wl[39] VDD pfet_03v3 L=0.28U W=2U AS=1.3P AD=1.3P PS=5.3U
+ PD=5.3U
M$201 \$525 B|comp[41] VDD VDD pfet_03v3 L=0.28U W=2U AS=1.3P AD=1.3P PS=5.3U
+ PD=5.3U
M$202 \$526 B|comp[39] VDD VDD pfet_03v3 L=0.28U W=2U AS=1.3P AD=0.84P PS=5.3U
+ PD=2.84U
M$203 VDD B|comp[40] \$526 VDD pfet_03v3 L=0.28U W=2U AS=0.84P AD=0.84P
+ PS=2.84U PD=2.84U
M$204 \$526 \$525 VDD VDD pfet_03v3 L=0.28U W=2U AS=0.84P AD=1.3P PS=2.84U
+ PD=5.3U
M$205 VDD \$526 out|wl[40] VDD pfet_03v3 L=0.28U W=2U AS=1.3P AD=1.3P PS=5.3U
+ PD=5.3U
M$206 \$538 B|comp[42] VDD VDD pfet_03v3 L=0.28U W=2U AS=1.3P AD=1.3P PS=5.3U
+ PD=5.3U
M$207 \$539 B|comp[40] VDD VDD pfet_03v3 L=0.28U W=2U AS=1.3P AD=0.84P PS=5.3U
+ PD=2.84U
M$208 VDD B|comp[41] \$539 VDD pfet_03v3 L=0.28U W=2U AS=0.84P AD=0.84P
+ PS=2.84U PD=2.84U
M$209 \$539 \$538 VDD VDD pfet_03v3 L=0.28U W=2U AS=0.84P AD=1.3P PS=2.84U
+ PD=5.3U
M$210 VDD \$539 out|wl[41] VDD pfet_03v3 L=0.28U W=2U AS=1.3P AD=1.3P PS=5.3U
+ PD=5.3U
M$211 \$551 B|comp[43] VDD VDD pfet_03v3 L=0.28U W=2U AS=1.3P AD=1.3P PS=5.3U
+ PD=5.3U
M$212 \$552 B|comp[41] VDD VDD pfet_03v3 L=0.28U W=2U AS=1.3P AD=0.84P PS=5.3U
+ PD=2.84U
M$213 VDD B|comp[42] \$552 VDD pfet_03v3 L=0.28U W=2U AS=0.84P AD=0.84P
+ PS=2.84U PD=2.84U
M$214 \$552 \$551 VDD VDD pfet_03v3 L=0.28U W=2U AS=0.84P AD=1.3P PS=2.84U
+ PD=5.3U
M$215 VDD \$552 out|wl[42] VDD pfet_03v3 L=0.28U W=2U AS=1.3P AD=1.3P PS=5.3U
+ PD=5.3U
M$216 \$564 B|comp[44] VDD VDD pfet_03v3 L=0.28U W=2U AS=1.3P AD=1.3P PS=5.3U
+ PD=5.3U
M$217 \$565 B|comp[42] VDD VDD pfet_03v3 L=0.28U W=2U AS=1.3P AD=0.84P PS=5.3U
+ PD=2.84U
M$218 VDD B|comp[43] \$565 VDD pfet_03v3 L=0.28U W=2U AS=0.84P AD=0.84P
+ PS=2.84U PD=2.84U
M$219 \$565 \$564 VDD VDD pfet_03v3 L=0.28U W=2U AS=0.84P AD=1.3P PS=2.84U
+ PD=5.3U
M$220 VDD \$565 out|wl[43] VDD pfet_03v3 L=0.28U W=2U AS=1.3P AD=1.3P PS=5.3U
+ PD=5.3U
M$221 \$577 B|comp[45] VDD VDD pfet_03v3 L=0.28U W=2U AS=1.3P AD=1.3P PS=5.3U
+ PD=5.3U
M$222 \$578 B|comp[43] VDD VDD pfet_03v3 L=0.28U W=2U AS=1.3P AD=0.84P PS=5.3U
+ PD=2.84U
M$223 VDD B|comp[44] \$578 VDD pfet_03v3 L=0.28U W=2U AS=0.84P AD=0.84P
+ PS=2.84U PD=2.84U
M$224 \$578 \$577 VDD VDD pfet_03v3 L=0.28U W=2U AS=0.84P AD=1.3P PS=2.84U
+ PD=5.3U
M$225 VDD \$578 out|wl[44] VDD pfet_03v3 L=0.28U W=2U AS=1.3P AD=1.3P PS=5.3U
+ PD=5.3U
M$226 \$590 B|comp[46] VDD VDD pfet_03v3 L=0.28U W=2U AS=1.3P AD=1.3P PS=5.3U
+ PD=5.3U
M$227 \$591 B|comp[44] VDD VDD pfet_03v3 L=0.28U W=2U AS=1.3P AD=0.84P PS=5.3U
+ PD=2.84U
M$228 VDD B|comp[45] \$591 VDD pfet_03v3 L=0.28U W=2U AS=0.84P AD=0.84P
+ PS=2.84U PD=2.84U
M$229 \$591 \$590 VDD VDD pfet_03v3 L=0.28U W=2U AS=0.84P AD=1.3P PS=2.84U
+ PD=5.3U
M$230 VDD \$591 out|wl[45] VDD pfet_03v3 L=0.28U W=2U AS=1.3P AD=1.3P PS=5.3U
+ PD=5.3U
M$231 \$603 B|comp[47] VDD VDD pfet_03v3 L=0.28U W=2U AS=1.3P AD=1.3P PS=5.3U
+ PD=5.3U
M$232 \$604 B|comp[45] VDD VDD pfet_03v3 L=0.28U W=2U AS=1.3P AD=0.84P PS=5.3U
+ PD=2.84U
M$233 VDD B|comp[46] \$604 VDD pfet_03v3 L=0.28U W=2U AS=0.84P AD=0.84P
+ PS=2.84U PD=2.84U
M$234 \$604 \$603 VDD VDD pfet_03v3 L=0.28U W=2U AS=0.84P AD=1.3P PS=2.84U
+ PD=5.3U
M$235 VDD \$604 out|wl[46] VDD pfet_03v3 L=0.28U W=2U AS=1.3P AD=1.3P PS=5.3U
+ PD=5.3U
M$236 \$616 B|comp[48] VDD VDD pfet_03v3 L=0.28U W=2U AS=1.3P AD=1.3P PS=5.3U
+ PD=5.3U
M$237 \$617 B|comp[46] VDD VDD pfet_03v3 L=0.28U W=2U AS=1.3P AD=0.84P PS=5.3U
+ PD=2.84U
M$238 VDD B|comp[47] \$617 VDD pfet_03v3 L=0.28U W=2U AS=0.84P AD=0.84P
+ PS=2.84U PD=2.84U
M$239 \$617 \$616 VDD VDD pfet_03v3 L=0.28U W=2U AS=0.84P AD=1.3P PS=2.84U
+ PD=5.3U
M$240 VDD \$617 out|wl[47] VDD pfet_03v3 L=0.28U W=2U AS=1.3P AD=1.3P PS=5.3U
+ PD=5.3U
M$241 \$629 B|comp[49] VDD VDD pfet_03v3 L=0.28U W=2U AS=1.3P AD=1.3P PS=5.3U
+ PD=5.3U
M$242 \$630 B|comp[47] VDD VDD pfet_03v3 L=0.28U W=2U AS=1.3P AD=0.84P PS=5.3U
+ PD=2.84U
M$243 VDD B|comp[48] \$630 VDD pfet_03v3 L=0.28U W=2U AS=0.84P AD=0.84P
+ PS=2.84U PD=2.84U
M$244 \$630 \$629 VDD VDD pfet_03v3 L=0.28U W=2U AS=0.84P AD=1.3P PS=2.84U
+ PD=5.3U
M$245 VDD \$630 out|wl[48] VDD pfet_03v3 L=0.28U W=2U AS=1.3P AD=1.3P PS=5.3U
+ PD=5.3U
M$246 \$642 B|comp[50] VDD VDD pfet_03v3 L=0.28U W=2U AS=1.3P AD=1.3P PS=5.3U
+ PD=5.3U
M$247 \$643 B|comp[48] VDD VDD pfet_03v3 L=0.28U W=2U AS=1.3P AD=0.84P PS=5.3U
+ PD=2.84U
M$248 VDD B|comp[49] \$643 VDD pfet_03v3 L=0.28U W=2U AS=0.84P AD=0.84P
+ PS=2.84U PD=2.84U
M$249 \$643 \$642 VDD VDD pfet_03v3 L=0.28U W=2U AS=0.84P AD=1.3P PS=2.84U
+ PD=5.3U
M$250 VDD \$643 out|wl[49] VDD pfet_03v3 L=0.28U W=2U AS=1.3P AD=1.3P PS=5.3U
+ PD=5.3U
M$251 \$655 B|comp[51] VDD VDD pfet_03v3 L=0.28U W=2U AS=1.3P AD=1.3P PS=5.3U
+ PD=5.3U
M$252 \$656 B|comp[49] VDD VDD pfet_03v3 L=0.28U W=2U AS=1.3P AD=0.84P PS=5.3U
+ PD=2.84U
M$253 VDD B|comp[50] \$656 VDD pfet_03v3 L=0.28U W=2U AS=0.84P AD=0.84P
+ PS=2.84U PD=2.84U
M$254 \$656 \$655 VDD VDD pfet_03v3 L=0.28U W=2U AS=0.84P AD=1.3P PS=2.84U
+ PD=5.3U
M$255 VDD \$656 out|wl[50] VDD pfet_03v3 L=0.28U W=2U AS=1.3P AD=1.3P PS=5.3U
+ PD=5.3U
M$256 \$668 B|comp[52] VDD VDD pfet_03v3 L=0.28U W=2U AS=1.3P AD=1.3P PS=5.3U
+ PD=5.3U
M$257 \$669 B|comp[50] VDD VDD pfet_03v3 L=0.28U W=2U AS=1.3P AD=0.84P PS=5.3U
+ PD=2.84U
M$258 VDD B|comp[51] \$669 VDD pfet_03v3 L=0.28U W=2U AS=0.84P AD=0.84P
+ PS=2.84U PD=2.84U
M$259 \$669 \$668 VDD VDD pfet_03v3 L=0.28U W=2U AS=0.84P AD=1.3P PS=2.84U
+ PD=5.3U
M$260 VDD \$669 out|wl[51] VDD pfet_03v3 L=0.28U W=2U AS=1.3P AD=1.3P PS=5.3U
+ PD=5.3U
M$261 \$681 B|comp[53] VDD VDD pfet_03v3 L=0.28U W=2U AS=1.3P AD=1.3P PS=5.3U
+ PD=5.3U
M$262 \$682 B|comp[51] VDD VDD pfet_03v3 L=0.28U W=2U AS=1.3P AD=0.84P PS=5.3U
+ PD=2.84U
M$263 VDD B|comp[52] \$682 VDD pfet_03v3 L=0.28U W=2U AS=0.84P AD=0.84P
+ PS=2.84U PD=2.84U
M$264 \$682 \$681 VDD VDD pfet_03v3 L=0.28U W=2U AS=0.84P AD=1.3P PS=2.84U
+ PD=5.3U
M$265 VDD \$682 out|wl[52] VDD pfet_03v3 L=0.28U W=2U AS=1.3P AD=1.3P PS=5.3U
+ PD=5.3U
M$266 \$694 B|comp[54] VDD VDD pfet_03v3 L=0.28U W=2U AS=1.3P AD=1.3P PS=5.3U
+ PD=5.3U
M$267 \$695 B|comp[52] VDD VDD pfet_03v3 L=0.28U W=2U AS=1.3P AD=0.84P PS=5.3U
+ PD=2.84U
M$268 VDD B|comp[53] \$695 VDD pfet_03v3 L=0.28U W=2U AS=0.84P AD=0.84P
+ PS=2.84U PD=2.84U
M$269 \$695 \$694 VDD VDD pfet_03v3 L=0.28U W=2U AS=0.84P AD=1.3P PS=2.84U
+ PD=5.3U
M$270 VDD \$695 out|wl[53] VDD pfet_03v3 L=0.28U W=2U AS=1.3P AD=1.3P PS=5.3U
+ PD=5.3U
M$271 \$707 B|comp[55] VDD VDD pfet_03v3 L=0.28U W=2U AS=1.3P AD=1.3P PS=5.3U
+ PD=5.3U
M$272 \$708 B|comp[53] VDD VDD pfet_03v3 L=0.28U W=2U AS=1.3P AD=0.84P PS=5.3U
+ PD=2.84U
M$273 VDD B|comp[54] \$708 VDD pfet_03v3 L=0.28U W=2U AS=0.84P AD=0.84P
+ PS=2.84U PD=2.84U
M$274 \$708 \$707 VDD VDD pfet_03v3 L=0.28U W=2U AS=0.84P AD=1.3P PS=2.84U
+ PD=5.3U
M$275 VDD \$708 out|wl[54] VDD pfet_03v3 L=0.28U W=2U AS=1.3P AD=1.3P PS=5.3U
+ PD=5.3U
M$276 \$720 B|comp[56] VDD VDD pfet_03v3 L=0.28U W=2U AS=1.3P AD=1.3P PS=5.3U
+ PD=5.3U
M$277 \$721 B|comp[54] VDD VDD pfet_03v3 L=0.28U W=2U AS=1.3P AD=0.84P PS=5.3U
+ PD=2.84U
M$278 VDD B|comp[55] \$721 VDD pfet_03v3 L=0.28U W=2U AS=0.84P AD=0.84P
+ PS=2.84U PD=2.84U
M$279 \$721 \$720 VDD VDD pfet_03v3 L=0.28U W=2U AS=0.84P AD=1.3P PS=2.84U
+ PD=5.3U
M$280 VDD \$721 out|wl[55] VDD pfet_03v3 L=0.28U W=2U AS=1.3P AD=1.3P PS=5.3U
+ PD=5.3U
M$281 \$733 B|comp[57] VDD VDD pfet_03v3 L=0.28U W=2U AS=1.3P AD=1.3P PS=5.3U
+ PD=5.3U
M$282 \$734 B|comp[55] VDD VDD pfet_03v3 L=0.28U W=2U AS=1.3P AD=0.84P PS=5.3U
+ PD=2.84U
M$283 VDD B|comp[56] \$734 VDD pfet_03v3 L=0.28U W=2U AS=0.84P AD=0.84P
+ PS=2.84U PD=2.84U
M$284 \$734 \$733 VDD VDD pfet_03v3 L=0.28U W=2U AS=0.84P AD=1.3P PS=2.84U
+ PD=5.3U
M$285 VDD \$734 out|wl[56] VDD pfet_03v3 L=0.28U W=2U AS=1.3P AD=1.3P PS=5.3U
+ PD=5.3U
M$286 \$746 B|comp[58] VDD VDD pfet_03v3 L=0.28U W=2U AS=1.3P AD=1.3P PS=5.3U
+ PD=5.3U
M$287 \$747 B|comp[56] VDD VDD pfet_03v3 L=0.28U W=2U AS=1.3P AD=0.84P PS=5.3U
+ PD=2.84U
M$288 VDD B|comp[57] \$747 VDD pfet_03v3 L=0.28U W=2U AS=0.84P AD=0.84P
+ PS=2.84U PD=2.84U
M$289 \$747 \$746 VDD VDD pfet_03v3 L=0.28U W=2U AS=0.84P AD=1.3P PS=2.84U
+ PD=5.3U
M$290 VDD \$747 out|wl[57] VDD pfet_03v3 L=0.28U W=2U AS=1.3P AD=1.3P PS=5.3U
+ PD=5.3U
M$291 \$759 B|comp[59] VDD VDD pfet_03v3 L=0.28U W=2U AS=1.3P AD=1.3P PS=5.3U
+ PD=5.3U
M$292 \$760 B|comp[57] VDD VDD pfet_03v3 L=0.28U W=2U AS=1.3P AD=0.84P PS=5.3U
+ PD=2.84U
M$293 VDD B|comp[58] \$760 VDD pfet_03v3 L=0.28U W=2U AS=0.84P AD=0.84P
+ PS=2.84U PD=2.84U
M$294 \$760 \$759 VDD VDD pfet_03v3 L=0.28U W=2U AS=0.84P AD=1.3P PS=2.84U
+ PD=5.3U
M$295 VDD \$760 out|wl[58] VDD pfet_03v3 L=0.28U W=2U AS=1.3P AD=1.3P PS=5.3U
+ PD=5.3U
M$296 \$772 B|comp[60] VDD VDD pfet_03v3 L=0.28U W=2U AS=1.3P AD=1.3P PS=5.3U
+ PD=5.3U
M$297 \$773 B|comp[58] VDD VDD pfet_03v3 L=0.28U W=2U AS=1.3P AD=0.84P PS=5.3U
+ PD=2.84U
M$298 VDD B|comp[59] \$773 VDD pfet_03v3 L=0.28U W=2U AS=0.84P AD=0.84P
+ PS=2.84U PD=2.84U
M$299 \$773 \$772 VDD VDD pfet_03v3 L=0.28U W=2U AS=0.84P AD=1.3P PS=2.84U
+ PD=5.3U
M$300 VDD \$773 out|wl[59] VDD pfet_03v3 L=0.28U W=2U AS=1.3P AD=1.3P PS=5.3U
+ PD=5.3U
M$301 \$785 B|comp[61] VDD VDD pfet_03v3 L=0.28U W=2U AS=1.3P AD=1.3P PS=5.3U
+ PD=5.3U
M$302 \$786 B|comp[59] VDD VDD pfet_03v3 L=0.28U W=2U AS=1.3P AD=0.84P PS=5.3U
+ PD=2.84U
M$303 VDD B|comp[60] \$786 VDD pfet_03v3 L=0.28U W=2U AS=0.84P AD=0.84P
+ PS=2.84U PD=2.84U
M$304 \$786 \$785 VDD VDD pfet_03v3 L=0.28U W=2U AS=0.84P AD=1.3P PS=2.84U
+ PD=5.3U
M$305 VDD \$786 out|wl[60] VDD pfet_03v3 L=0.28U W=2U AS=1.3P AD=1.3P PS=5.3U
+ PD=5.3U
M$306 \$798 B|comp[62] VDD VDD pfet_03v3 L=0.28U W=2U AS=1.3P AD=1.3P PS=5.3U
+ PD=5.3U
M$307 \$799 B|comp[60] VDD VDD pfet_03v3 L=0.28U W=2U AS=1.3P AD=0.84P PS=5.3U
+ PD=2.84U
M$308 VDD B|comp[61] \$799 VDD pfet_03v3 L=0.28U W=2U AS=0.84P AD=0.84P
+ PS=2.84U PD=2.84U
M$309 \$799 \$798 VDD VDD pfet_03v3 L=0.28U W=2U AS=0.84P AD=1.3P PS=2.84U
+ PD=5.3U
M$310 VDD \$799 out|wl[61] VDD pfet_03v3 L=0.28U W=2U AS=1.3P AD=1.3P PS=5.3U
+ PD=5.3U
M$311 \$811 GND VDD VDD pfet_03v3 L=0.28U W=2U AS=1.3P AD=1.3P PS=5.3U PD=5.3U
M$312 \$812 B|comp[61] VDD VDD pfet_03v3 L=0.28U W=2U AS=1.3P AD=0.84P PS=5.3U
+ PD=2.84U
M$313 VDD B|comp[62] \$812 VDD pfet_03v3 L=0.28U W=2U AS=0.84P AD=0.84P
+ PS=2.84U PD=2.84U
M$314 \$812 \$811 VDD VDD pfet_03v3 L=0.28U W=2U AS=0.84P AD=1.3P PS=2.84U
+ PD=5.3U
M$315 VDD \$812 out|wl[62] VDD pfet_03v3 L=0.28U W=2U AS=1.3P AD=1.3P PS=5.3U
+ PD=5.3U
M$316 \$2 B|comp[1] GND GND nfet_03v3 L=0.28U W=1U AS=0.61P AD=0.61P PS=3.22U
+ PD=3.22U
M$317 \$4 VDD \$3 GND nfet_03v3 L=0.28U W=1U AS=0.61P AD=0.4P PS=3.22U PD=1.8U
M$318 \$5 B|comp[0] \$4 GND nfet_03v3 L=0.28U W=1U AS=0.4P AD=0.4P PS=1.8U
+ PD=1.8U
M$319 GND \$2 \$5 GND nfet_03v3 L=0.28U W=1U AS=0.4P AD=0.61P PS=1.8U PD=3.22U
M$320 GND \$3 out|wl[0] GND nfet_03v3 L=0.28U W=1U AS=0.61P AD=0.61P PS=3.22U
+ PD=3.22U
M$321 \$18 B|comp[2] GND GND nfet_03v3 L=0.28U W=1U AS=0.61P AD=0.61P PS=3.22U
+ PD=3.22U
M$322 \$26 B|comp[0] \$19 GND nfet_03v3 L=0.28U W=1U AS=0.61P AD=0.4P PS=3.22U
+ PD=1.8U
M$323 \$27 B|comp[1] \$26 GND nfet_03v3 L=0.28U W=1U AS=0.4P AD=0.4P PS=1.8U
+ PD=1.8U
M$324 GND \$18 \$27 GND nfet_03v3 L=0.28U W=1U AS=0.4P AD=0.61P PS=1.8U PD=3.22U
M$325 GND \$19 out|wl[1] GND nfet_03v3 L=0.28U W=1U AS=0.61P AD=0.61P PS=3.22U
+ PD=3.22U
M$326 \$31 B|comp[3] GND GND nfet_03v3 L=0.28U W=1U AS=0.61P AD=0.61P PS=3.22U
+ PD=3.22U
M$327 \$33 B|comp[1] \$32 GND nfet_03v3 L=0.28U W=1U AS=0.61P AD=0.4P PS=3.22U
+ PD=1.8U
M$328 \$34 B|comp[2] \$33 GND nfet_03v3 L=0.28U W=1U AS=0.4P AD=0.4P PS=1.8U
+ PD=1.8U
M$329 GND \$31 \$34 GND nfet_03v3 L=0.28U W=1U AS=0.4P AD=0.61P PS=1.8U PD=3.22U
M$330 GND \$32 out|wl[2] GND nfet_03v3 L=0.28U W=1U AS=0.61P AD=0.61P PS=3.22U
+ PD=3.22U
M$331 \$44 B|comp[4] GND GND nfet_03v3 L=0.28U W=1U AS=0.61P AD=0.61P PS=3.22U
+ PD=3.22U
M$332 \$52 B|comp[2] \$45 GND nfet_03v3 L=0.28U W=1U AS=0.61P AD=0.4P PS=3.22U
+ PD=1.8U
M$333 \$53 B|comp[3] \$52 GND nfet_03v3 L=0.28U W=1U AS=0.4P AD=0.4P PS=1.8U
+ PD=1.8U
M$334 GND \$44 \$53 GND nfet_03v3 L=0.28U W=1U AS=0.4P AD=0.61P PS=1.8U PD=3.22U
M$335 GND \$45 out|wl[3] GND nfet_03v3 L=0.28U W=1U AS=0.61P AD=0.61P PS=3.22U
+ PD=3.22U
M$336 \$57 B|comp[5] GND GND nfet_03v3 L=0.28U W=1U AS=0.61P AD=0.61P PS=3.22U
+ PD=3.22U
M$337 \$59 B|comp[3] \$58 GND nfet_03v3 L=0.28U W=1U AS=0.61P AD=0.4P PS=3.22U
+ PD=1.8U
M$338 \$60 B|comp[4] \$59 GND nfet_03v3 L=0.28U W=1U AS=0.4P AD=0.4P PS=1.8U
+ PD=1.8U
M$339 GND \$57 \$60 GND nfet_03v3 L=0.28U W=1U AS=0.4P AD=0.61P PS=1.8U PD=3.22U
M$340 GND \$58 out|wl[4] GND nfet_03v3 L=0.28U W=1U AS=0.61P AD=0.61P PS=3.22U
+ PD=3.22U
M$341 \$70 B|comp[6] GND GND nfet_03v3 L=0.28U W=1U AS=0.61P AD=0.61P PS=3.22U
+ PD=3.22U
M$342 \$78 B|comp[4] \$71 GND nfet_03v3 L=0.28U W=1U AS=0.61P AD=0.4P PS=3.22U
+ PD=1.8U
M$343 \$79 B|comp[5] \$78 GND nfet_03v3 L=0.28U W=1U AS=0.4P AD=0.4P PS=1.8U
+ PD=1.8U
M$344 GND \$70 \$79 GND nfet_03v3 L=0.28U W=1U AS=0.4P AD=0.61P PS=1.8U PD=3.22U
M$345 GND \$71 out|wl[5] GND nfet_03v3 L=0.28U W=1U AS=0.61P AD=0.61P PS=3.22U
+ PD=3.22U
M$346 \$83 B|comp[7] GND GND nfet_03v3 L=0.28U W=1U AS=0.61P AD=0.61P PS=3.22U
+ PD=3.22U
M$347 \$85 B|comp[5] \$84 GND nfet_03v3 L=0.28U W=1U AS=0.61P AD=0.4P PS=3.22U
+ PD=1.8U
M$348 \$86 B|comp[6] \$85 GND nfet_03v3 L=0.28U W=1U AS=0.4P AD=0.4P PS=1.8U
+ PD=1.8U
M$349 GND \$83 \$86 GND nfet_03v3 L=0.28U W=1U AS=0.4P AD=0.61P PS=1.8U PD=3.22U
M$350 GND \$84 out|wl[6] GND nfet_03v3 L=0.28U W=1U AS=0.61P AD=0.61P PS=3.22U
+ PD=3.22U
M$351 \$96 B|comp[8] GND GND nfet_03v3 L=0.28U W=1U AS=0.61P AD=0.61P PS=3.22U
+ PD=3.22U
M$352 \$104 B|comp[6] \$97 GND nfet_03v3 L=0.28U W=1U AS=0.61P AD=0.4P PS=3.22U
+ PD=1.8U
M$353 \$105 B|comp[7] \$104 GND nfet_03v3 L=0.28U W=1U AS=0.4P AD=0.4P PS=1.8U
+ PD=1.8U
M$354 GND \$96 \$105 GND nfet_03v3 L=0.28U W=1U AS=0.4P AD=0.61P PS=1.8U
+ PD=3.22U
M$355 GND \$97 out|wl[7] GND nfet_03v3 L=0.28U W=1U AS=0.61P AD=0.61P PS=3.22U
+ PD=3.22U
M$356 \$109 B|comp[9] GND GND nfet_03v3 L=0.28U W=1U AS=0.61P AD=0.61P PS=3.22U
+ PD=3.22U
M$357 \$111 B|comp[7] \$110 GND nfet_03v3 L=0.28U W=1U AS=0.61P AD=0.4P
+ PS=3.22U PD=1.8U
M$358 \$112 B|comp[8] \$111 GND nfet_03v3 L=0.28U W=1U AS=0.4P AD=0.4P PS=1.8U
+ PD=1.8U
M$359 GND \$109 \$112 GND nfet_03v3 L=0.28U W=1U AS=0.4P AD=0.61P PS=1.8U
+ PD=3.22U
M$360 GND \$110 out|wl[8] GND nfet_03v3 L=0.28U W=1U AS=0.61P AD=0.61P PS=3.22U
+ PD=3.22U
M$361 \$122 B|comp[10] GND GND nfet_03v3 L=0.28U W=1U AS=0.61P AD=0.61P
+ PS=3.22U PD=3.22U
M$362 \$130 B|comp[8] \$123 GND nfet_03v3 L=0.28U W=1U AS=0.61P AD=0.4P
+ PS=3.22U PD=1.8U
M$363 \$131 B|comp[9] \$130 GND nfet_03v3 L=0.28U W=1U AS=0.4P AD=0.4P PS=1.8U
+ PD=1.8U
M$364 GND \$122 \$131 GND nfet_03v3 L=0.28U W=1U AS=0.4P AD=0.61P PS=1.8U
+ PD=3.22U
M$365 GND \$123 out|wl[9] GND nfet_03v3 L=0.28U W=1U AS=0.61P AD=0.61P PS=3.22U
+ PD=3.22U
M$366 \$135 B|comp[11] GND GND nfet_03v3 L=0.28U W=1U AS=0.61P AD=0.61P
+ PS=3.22U PD=3.22U
M$367 \$137 B|comp[9] \$136 GND nfet_03v3 L=0.28U W=1U AS=0.61P AD=0.4P
+ PS=3.22U PD=1.8U
M$368 \$138 B|comp[10] \$137 GND nfet_03v3 L=0.28U W=1U AS=0.4P AD=0.4P PS=1.8U
+ PD=1.8U
M$369 GND \$135 \$138 GND nfet_03v3 L=0.28U W=1U AS=0.4P AD=0.61P PS=1.8U
+ PD=3.22U
M$370 GND \$136 out|wl[10] GND nfet_03v3 L=0.28U W=1U AS=0.61P AD=0.61P
+ PS=3.22U PD=3.22U
M$371 \$148 B|comp[12] GND GND nfet_03v3 L=0.28U W=1U AS=0.61P AD=0.61P
+ PS=3.22U PD=3.22U
M$372 \$156 B|comp[10] \$149 GND nfet_03v3 L=0.28U W=1U AS=0.61P AD=0.4P
+ PS=3.22U PD=1.8U
M$373 \$157 B|comp[11] \$156 GND nfet_03v3 L=0.28U W=1U AS=0.4P AD=0.4P PS=1.8U
+ PD=1.8U
M$374 GND \$148 \$157 GND nfet_03v3 L=0.28U W=1U AS=0.4P AD=0.61P PS=1.8U
+ PD=3.22U
M$375 GND \$149 out|wl[11] GND nfet_03v3 L=0.28U W=1U AS=0.61P AD=0.61P
+ PS=3.22U PD=3.22U
M$376 \$161 B|comp[13] GND GND nfet_03v3 L=0.28U W=1U AS=0.61P AD=0.61P
+ PS=3.22U PD=3.22U
M$377 \$163 B|comp[11] \$162 GND nfet_03v3 L=0.28U W=1U AS=0.61P AD=0.4P
+ PS=3.22U PD=1.8U
M$378 \$164 B|comp[12] \$163 GND nfet_03v3 L=0.28U W=1U AS=0.4P AD=0.4P PS=1.8U
+ PD=1.8U
M$379 GND \$161 \$164 GND nfet_03v3 L=0.28U W=1U AS=0.4P AD=0.61P PS=1.8U
+ PD=3.22U
M$380 GND \$162 out|wl[12] GND nfet_03v3 L=0.28U W=1U AS=0.61P AD=0.61P
+ PS=3.22U PD=3.22U
M$381 \$174 B|comp[14] GND GND nfet_03v3 L=0.28U W=1U AS=0.61P AD=0.61P
+ PS=3.22U PD=3.22U
M$382 \$182 B|comp[12] \$175 GND nfet_03v3 L=0.28U W=1U AS=0.61P AD=0.4P
+ PS=3.22U PD=1.8U
M$383 \$183 B|comp[13] \$182 GND nfet_03v3 L=0.28U W=1U AS=0.4P AD=0.4P PS=1.8U
+ PD=1.8U
M$384 GND \$174 \$183 GND nfet_03v3 L=0.28U W=1U AS=0.4P AD=0.61P PS=1.8U
+ PD=3.22U
M$385 GND \$175 out|wl[13] GND nfet_03v3 L=0.28U W=1U AS=0.61P AD=0.61P
+ PS=3.22U PD=3.22U
M$386 \$187 B|comp[15] GND GND nfet_03v3 L=0.28U W=1U AS=0.61P AD=0.61P
+ PS=3.22U PD=3.22U
M$387 \$189 B|comp[13] \$188 GND nfet_03v3 L=0.28U W=1U AS=0.61P AD=0.4P
+ PS=3.22U PD=1.8U
M$388 \$190 B|comp[14] \$189 GND nfet_03v3 L=0.28U W=1U AS=0.4P AD=0.4P PS=1.8U
+ PD=1.8U
M$389 GND \$187 \$190 GND nfet_03v3 L=0.28U W=1U AS=0.4P AD=0.61P PS=1.8U
+ PD=3.22U
M$390 GND \$188 out|wl[14] GND nfet_03v3 L=0.28U W=1U AS=0.61P AD=0.61P
+ PS=3.22U PD=3.22U
M$391 \$200 B|comp[16] GND GND nfet_03v3 L=0.28U W=1U AS=0.61P AD=0.61P
+ PS=3.22U PD=3.22U
M$392 \$208 B|comp[14] \$201 GND nfet_03v3 L=0.28U W=1U AS=0.61P AD=0.4P
+ PS=3.22U PD=1.8U
M$393 \$209 B|comp[15] \$208 GND nfet_03v3 L=0.28U W=1U AS=0.4P AD=0.4P PS=1.8U
+ PD=1.8U
M$394 GND \$200 \$209 GND nfet_03v3 L=0.28U W=1U AS=0.4P AD=0.61P PS=1.8U
+ PD=3.22U
M$395 GND \$201 out|wl[15] GND nfet_03v3 L=0.28U W=1U AS=0.61P AD=0.61P
+ PS=3.22U PD=3.22U
M$396 \$213 B|comp[17] GND GND nfet_03v3 L=0.28U W=1U AS=0.61P AD=0.61P
+ PS=3.22U PD=3.22U
M$397 \$215 B|comp[15] \$214 GND nfet_03v3 L=0.28U W=1U AS=0.61P AD=0.4P
+ PS=3.22U PD=1.8U
M$398 \$216 B|comp[16] \$215 GND nfet_03v3 L=0.28U W=1U AS=0.4P AD=0.4P PS=1.8U
+ PD=1.8U
M$399 GND \$213 \$216 GND nfet_03v3 L=0.28U W=1U AS=0.4P AD=0.61P PS=1.8U
+ PD=3.22U
M$400 GND \$214 out|wl[16] GND nfet_03v3 L=0.28U W=1U AS=0.61P AD=0.61P
+ PS=3.22U PD=3.22U
M$401 \$226 B|comp[18] GND GND nfet_03v3 L=0.28U W=1U AS=0.61P AD=0.61P
+ PS=3.22U PD=3.22U
M$402 \$234 B|comp[16] \$227 GND nfet_03v3 L=0.28U W=1U AS=0.61P AD=0.4P
+ PS=3.22U PD=1.8U
M$403 \$235 B|comp[17] \$234 GND nfet_03v3 L=0.28U W=1U AS=0.4P AD=0.4P PS=1.8U
+ PD=1.8U
M$404 GND \$226 \$235 GND nfet_03v3 L=0.28U W=1U AS=0.4P AD=0.61P PS=1.8U
+ PD=3.22U
M$405 GND \$227 out|wl[17] GND nfet_03v3 L=0.28U W=1U AS=0.61P AD=0.61P
+ PS=3.22U PD=3.22U
M$406 \$239 B|comp[19] GND GND nfet_03v3 L=0.28U W=1U AS=0.61P AD=0.61P
+ PS=3.22U PD=3.22U
M$407 \$241 B|comp[17] \$240 GND nfet_03v3 L=0.28U W=1U AS=0.61P AD=0.4P
+ PS=3.22U PD=1.8U
M$408 \$242 B|comp[18] \$241 GND nfet_03v3 L=0.28U W=1U AS=0.4P AD=0.4P PS=1.8U
+ PD=1.8U
M$409 GND \$239 \$242 GND nfet_03v3 L=0.28U W=1U AS=0.4P AD=0.61P PS=1.8U
+ PD=3.22U
M$410 GND \$240 out|wl[18] GND nfet_03v3 L=0.28U W=1U AS=0.61P AD=0.61P
+ PS=3.22U PD=3.22U
M$411 \$252 B|comp[20] GND GND nfet_03v3 L=0.28U W=1U AS=0.61P AD=0.61P
+ PS=3.22U PD=3.22U
M$412 \$260 B|comp[18] \$253 GND nfet_03v3 L=0.28U W=1U AS=0.61P AD=0.4P
+ PS=3.22U PD=1.8U
M$413 \$261 B|comp[19] \$260 GND nfet_03v3 L=0.28U W=1U AS=0.4P AD=0.4P PS=1.8U
+ PD=1.8U
M$414 GND \$252 \$261 GND nfet_03v3 L=0.28U W=1U AS=0.4P AD=0.61P PS=1.8U
+ PD=3.22U
M$415 GND \$253 out|wl[19] GND nfet_03v3 L=0.28U W=1U AS=0.61P AD=0.61P
+ PS=3.22U PD=3.22U
M$416 \$265 B|comp[21] GND GND nfet_03v3 L=0.28U W=1U AS=0.61P AD=0.61P
+ PS=3.22U PD=3.22U
M$417 \$267 B|comp[19] \$266 GND nfet_03v3 L=0.28U W=1U AS=0.61P AD=0.4P
+ PS=3.22U PD=1.8U
M$418 \$268 B|comp[20] \$267 GND nfet_03v3 L=0.28U W=1U AS=0.4P AD=0.4P PS=1.8U
+ PD=1.8U
M$419 GND \$265 \$268 GND nfet_03v3 L=0.28U W=1U AS=0.4P AD=0.61P PS=1.8U
+ PD=3.22U
M$420 GND \$266 out|wl[20] GND nfet_03v3 L=0.28U W=1U AS=0.61P AD=0.61P
+ PS=3.22U PD=3.22U
M$421 \$278 B|comp[22] GND GND nfet_03v3 L=0.28U W=1U AS=0.61P AD=0.61P
+ PS=3.22U PD=3.22U
M$422 \$286 B|comp[20] \$279 GND nfet_03v3 L=0.28U W=1U AS=0.61P AD=0.4P
+ PS=3.22U PD=1.8U
M$423 \$287 B|comp[21] \$286 GND nfet_03v3 L=0.28U W=1U AS=0.4P AD=0.4P PS=1.8U
+ PD=1.8U
M$424 GND \$278 \$287 GND nfet_03v3 L=0.28U W=1U AS=0.4P AD=0.61P PS=1.8U
+ PD=3.22U
M$425 GND \$279 out|wl[21] GND nfet_03v3 L=0.28U W=1U AS=0.61P AD=0.61P
+ PS=3.22U PD=3.22U
M$426 \$291 B|comp[23] GND GND nfet_03v3 L=0.28U W=1U AS=0.61P AD=0.61P
+ PS=3.22U PD=3.22U
M$427 \$293 B|comp[21] \$292 GND nfet_03v3 L=0.28U W=1U AS=0.61P AD=0.4P
+ PS=3.22U PD=1.8U
M$428 \$294 B|comp[22] \$293 GND nfet_03v3 L=0.28U W=1U AS=0.4P AD=0.4P PS=1.8U
+ PD=1.8U
M$429 GND \$291 \$294 GND nfet_03v3 L=0.28U W=1U AS=0.4P AD=0.61P PS=1.8U
+ PD=3.22U
M$430 GND \$292 out|wl[22] GND nfet_03v3 L=0.28U W=1U AS=0.61P AD=0.61P
+ PS=3.22U PD=3.22U
M$431 \$304 B|comp[24] GND GND nfet_03v3 L=0.28U W=1U AS=0.61P AD=0.61P
+ PS=3.22U PD=3.22U
M$432 \$312 B|comp[22] \$305 GND nfet_03v3 L=0.28U W=1U AS=0.61P AD=0.4P
+ PS=3.22U PD=1.8U
M$433 \$313 B|comp[23] \$312 GND nfet_03v3 L=0.28U W=1U AS=0.4P AD=0.4P PS=1.8U
+ PD=1.8U
M$434 GND \$304 \$313 GND nfet_03v3 L=0.28U W=1U AS=0.4P AD=0.61P PS=1.8U
+ PD=3.22U
M$435 GND \$305 out|wl[23] GND nfet_03v3 L=0.28U W=1U AS=0.61P AD=0.61P
+ PS=3.22U PD=3.22U
M$436 \$317 B|comp[25] GND GND nfet_03v3 L=0.28U W=1U AS=0.61P AD=0.61P
+ PS=3.22U PD=3.22U
M$437 \$319 B|comp[23] \$318 GND nfet_03v3 L=0.28U W=1U AS=0.61P AD=0.4P
+ PS=3.22U PD=1.8U
M$438 \$320 B|comp[24] \$319 GND nfet_03v3 L=0.28U W=1U AS=0.4P AD=0.4P PS=1.8U
+ PD=1.8U
M$439 GND \$317 \$320 GND nfet_03v3 L=0.28U W=1U AS=0.4P AD=0.61P PS=1.8U
+ PD=3.22U
M$440 GND \$318 out|wl[24] GND nfet_03v3 L=0.28U W=1U AS=0.61P AD=0.61P
+ PS=3.22U PD=3.22U
M$441 \$330 B|comp[26] GND GND nfet_03v3 L=0.28U W=1U AS=0.61P AD=0.61P
+ PS=3.22U PD=3.22U
M$442 \$338 B|comp[24] \$331 GND nfet_03v3 L=0.28U W=1U AS=0.61P AD=0.4P
+ PS=3.22U PD=1.8U
M$443 \$339 B|comp[25] \$338 GND nfet_03v3 L=0.28U W=1U AS=0.4P AD=0.4P PS=1.8U
+ PD=1.8U
M$444 GND \$330 \$339 GND nfet_03v3 L=0.28U W=1U AS=0.4P AD=0.61P PS=1.8U
+ PD=3.22U
M$445 GND \$331 out|wl[25] GND nfet_03v3 L=0.28U W=1U AS=0.61P AD=0.61P
+ PS=3.22U PD=3.22U
M$446 \$343 B|comp[27] GND GND nfet_03v3 L=0.28U W=1U AS=0.61P AD=0.61P
+ PS=3.22U PD=3.22U
M$447 \$345 B|comp[25] \$344 GND nfet_03v3 L=0.28U W=1U AS=0.61P AD=0.4P
+ PS=3.22U PD=1.8U
M$448 \$346 B|comp[26] \$345 GND nfet_03v3 L=0.28U W=1U AS=0.4P AD=0.4P PS=1.8U
+ PD=1.8U
M$449 GND \$343 \$346 GND nfet_03v3 L=0.28U W=1U AS=0.4P AD=0.61P PS=1.8U
+ PD=3.22U
M$450 GND \$344 out|wl[26] GND nfet_03v3 L=0.28U W=1U AS=0.61P AD=0.61P
+ PS=3.22U PD=3.22U
M$451 \$356 B|comp[28] GND GND nfet_03v3 L=0.28U W=1U AS=0.61P AD=0.61P
+ PS=3.22U PD=3.22U
M$452 \$364 B|comp[26] \$357 GND nfet_03v3 L=0.28U W=1U AS=0.61P AD=0.4P
+ PS=3.22U PD=1.8U
M$453 \$365 B|comp[27] \$364 GND nfet_03v3 L=0.28U W=1U AS=0.4P AD=0.4P PS=1.8U
+ PD=1.8U
M$454 GND \$356 \$365 GND nfet_03v3 L=0.28U W=1U AS=0.4P AD=0.61P PS=1.8U
+ PD=3.22U
M$455 GND \$357 out|wl[27] GND nfet_03v3 L=0.28U W=1U AS=0.61P AD=0.61P
+ PS=3.22U PD=3.22U
M$456 \$369 B|comp[29] GND GND nfet_03v3 L=0.28U W=1U AS=0.61P AD=0.61P
+ PS=3.22U PD=3.22U
M$457 \$371 B|comp[27] \$370 GND nfet_03v3 L=0.28U W=1U AS=0.61P AD=0.4P
+ PS=3.22U PD=1.8U
M$458 \$372 B|comp[28] \$371 GND nfet_03v3 L=0.28U W=1U AS=0.4P AD=0.4P PS=1.8U
+ PD=1.8U
M$459 GND \$369 \$372 GND nfet_03v3 L=0.28U W=1U AS=0.4P AD=0.61P PS=1.8U
+ PD=3.22U
M$460 GND \$370 out|wl[28] GND nfet_03v3 L=0.28U W=1U AS=0.61P AD=0.61P
+ PS=3.22U PD=3.22U
M$461 \$382 B|comp[30] GND GND nfet_03v3 L=0.28U W=1U AS=0.61P AD=0.61P
+ PS=3.22U PD=3.22U
M$462 \$390 B|comp[28] \$383 GND nfet_03v3 L=0.28U W=1U AS=0.61P AD=0.4P
+ PS=3.22U PD=1.8U
M$463 \$391 B|comp[29] \$390 GND nfet_03v3 L=0.28U W=1U AS=0.4P AD=0.4P PS=1.8U
+ PD=1.8U
M$464 GND \$382 \$391 GND nfet_03v3 L=0.28U W=1U AS=0.4P AD=0.61P PS=1.8U
+ PD=3.22U
M$465 GND \$383 out|wl[29] GND nfet_03v3 L=0.28U W=1U AS=0.61P AD=0.61P
+ PS=3.22U PD=3.22U
M$466 \$395 B|comp[31] GND GND nfet_03v3 L=0.28U W=1U AS=0.61P AD=0.61P
+ PS=3.22U PD=3.22U
M$467 \$397 B|comp[29] \$396 GND nfet_03v3 L=0.28U W=1U AS=0.61P AD=0.4P
+ PS=3.22U PD=1.8U
M$468 \$398 B|comp[30] \$397 GND nfet_03v3 L=0.28U W=1U AS=0.4P AD=0.4P PS=1.8U
+ PD=1.8U
M$469 GND \$395 \$398 GND nfet_03v3 L=0.28U W=1U AS=0.4P AD=0.61P PS=1.8U
+ PD=3.22U
M$470 GND \$396 out|wl[30] GND nfet_03v3 L=0.28U W=1U AS=0.61P AD=0.61P
+ PS=3.22U PD=3.22U
M$471 \$408 B|comp[32] GND GND nfet_03v3 L=0.28U W=1U AS=0.61P AD=0.61P
+ PS=3.22U PD=3.22U
M$472 \$416 B|comp[30] \$409 GND nfet_03v3 L=0.28U W=1U AS=0.61P AD=0.4P
+ PS=3.22U PD=1.8U
M$473 \$417 B|comp[31] \$416 GND nfet_03v3 L=0.28U W=1U AS=0.4P AD=0.4P PS=1.8U
+ PD=1.8U
M$474 GND \$408 \$417 GND nfet_03v3 L=0.28U W=1U AS=0.4P AD=0.61P PS=1.8U
+ PD=3.22U
M$475 GND \$409 out|wl[31] GND nfet_03v3 L=0.28U W=1U AS=0.61P AD=0.61P
+ PS=3.22U PD=3.22U
M$476 \$421 B|comp[33] GND GND nfet_03v3 L=0.28U W=1U AS=0.61P AD=0.61P
+ PS=3.22U PD=3.22U
M$477 \$423 B|comp[31] \$422 GND nfet_03v3 L=0.28U W=1U AS=0.61P AD=0.4P
+ PS=3.22U PD=1.8U
M$478 \$424 B|comp[32] \$423 GND nfet_03v3 L=0.28U W=1U AS=0.4P AD=0.4P PS=1.8U
+ PD=1.8U
M$479 GND \$421 \$424 GND nfet_03v3 L=0.28U W=1U AS=0.4P AD=0.61P PS=1.8U
+ PD=3.22U
M$480 GND \$422 out|wl[32] GND nfet_03v3 L=0.28U W=1U AS=0.61P AD=0.61P
+ PS=3.22U PD=3.22U
M$481 \$434 B|comp[34] GND GND nfet_03v3 L=0.28U W=1U AS=0.61P AD=0.61P
+ PS=3.22U PD=3.22U
M$482 \$442 B|comp[32] \$435 GND nfet_03v3 L=0.28U W=1U AS=0.61P AD=0.4P
+ PS=3.22U PD=1.8U
M$483 \$443 B|comp[33] \$442 GND nfet_03v3 L=0.28U W=1U AS=0.4P AD=0.4P PS=1.8U
+ PD=1.8U
M$484 GND \$434 \$443 GND nfet_03v3 L=0.28U W=1U AS=0.4P AD=0.61P PS=1.8U
+ PD=3.22U
M$485 GND \$435 out|wl[33] GND nfet_03v3 L=0.28U W=1U AS=0.61P AD=0.61P
+ PS=3.22U PD=3.22U
M$486 \$447 B|comp[35] GND GND nfet_03v3 L=0.28U W=1U AS=0.61P AD=0.61P
+ PS=3.22U PD=3.22U
M$487 \$449 B|comp[33] \$448 GND nfet_03v3 L=0.28U W=1U AS=0.61P AD=0.4P
+ PS=3.22U PD=1.8U
M$488 \$450 B|comp[34] \$449 GND nfet_03v3 L=0.28U W=1U AS=0.4P AD=0.4P PS=1.8U
+ PD=1.8U
M$489 GND \$447 \$450 GND nfet_03v3 L=0.28U W=1U AS=0.4P AD=0.61P PS=1.8U
+ PD=3.22U
M$490 GND \$448 out|wl[34] GND nfet_03v3 L=0.28U W=1U AS=0.61P AD=0.61P
+ PS=3.22U PD=3.22U
M$491 \$460 B|comp[36] GND GND nfet_03v3 L=0.28U W=1U AS=0.61P AD=0.61P
+ PS=3.22U PD=3.22U
M$492 \$468 B|comp[34] \$461 GND nfet_03v3 L=0.28U W=1U AS=0.61P AD=0.4P
+ PS=3.22U PD=1.8U
M$493 \$469 B|comp[35] \$468 GND nfet_03v3 L=0.28U W=1U AS=0.4P AD=0.4P PS=1.8U
+ PD=1.8U
M$494 GND \$460 \$469 GND nfet_03v3 L=0.28U W=1U AS=0.4P AD=0.61P PS=1.8U
+ PD=3.22U
M$495 GND \$461 out|wl[35] GND nfet_03v3 L=0.28U W=1U AS=0.61P AD=0.61P
+ PS=3.22U PD=3.22U
M$496 \$473 B|comp[37] GND GND nfet_03v3 L=0.28U W=1U AS=0.61P AD=0.61P
+ PS=3.22U PD=3.22U
M$497 \$475 B|comp[35] \$474 GND nfet_03v3 L=0.28U W=1U AS=0.61P AD=0.4P
+ PS=3.22U PD=1.8U
M$498 \$476 B|comp[36] \$475 GND nfet_03v3 L=0.28U W=1U AS=0.4P AD=0.4P PS=1.8U
+ PD=1.8U
M$499 GND \$473 \$476 GND nfet_03v3 L=0.28U W=1U AS=0.4P AD=0.61P PS=1.8U
+ PD=3.22U
M$500 GND \$474 out|wl[36] GND nfet_03v3 L=0.28U W=1U AS=0.61P AD=0.61P
+ PS=3.22U PD=3.22U
M$501 \$486 B|comp[38] GND GND nfet_03v3 L=0.28U W=1U AS=0.61P AD=0.61P
+ PS=3.22U PD=3.22U
M$502 \$494 B|comp[36] \$487 GND nfet_03v3 L=0.28U W=1U AS=0.61P AD=0.4P
+ PS=3.22U PD=1.8U
M$503 \$495 B|comp[37] \$494 GND nfet_03v3 L=0.28U W=1U AS=0.4P AD=0.4P PS=1.8U
+ PD=1.8U
M$504 GND \$486 \$495 GND nfet_03v3 L=0.28U W=1U AS=0.4P AD=0.61P PS=1.8U
+ PD=3.22U
M$505 GND \$487 out|wl[37] GND nfet_03v3 L=0.28U W=1U AS=0.61P AD=0.61P
+ PS=3.22U PD=3.22U
M$506 \$499 B|comp[39] GND GND nfet_03v3 L=0.28U W=1U AS=0.61P AD=0.61P
+ PS=3.22U PD=3.22U
M$507 \$501 B|comp[37] \$500 GND nfet_03v3 L=0.28U W=1U AS=0.61P AD=0.4P
+ PS=3.22U PD=1.8U
M$508 \$502 B|comp[38] \$501 GND nfet_03v3 L=0.28U W=1U AS=0.4P AD=0.4P PS=1.8U
+ PD=1.8U
M$509 GND \$499 \$502 GND nfet_03v3 L=0.28U W=1U AS=0.4P AD=0.61P PS=1.8U
+ PD=3.22U
M$510 GND \$500 out|wl[38] GND nfet_03v3 L=0.28U W=1U AS=0.61P AD=0.61P
+ PS=3.22U PD=3.22U
M$511 \$512 B|comp[40] GND GND nfet_03v3 L=0.28U W=1U AS=0.61P AD=0.61P
+ PS=3.22U PD=3.22U
M$512 \$520 B|comp[38] \$513 GND nfet_03v3 L=0.28U W=1U AS=0.61P AD=0.4P
+ PS=3.22U PD=1.8U
M$513 \$521 B|comp[39] \$520 GND nfet_03v3 L=0.28U W=1U AS=0.4P AD=0.4P PS=1.8U
+ PD=1.8U
M$514 GND \$512 \$521 GND nfet_03v3 L=0.28U W=1U AS=0.4P AD=0.61P PS=1.8U
+ PD=3.22U
M$515 GND \$513 out|wl[39] GND nfet_03v3 L=0.28U W=1U AS=0.61P AD=0.61P
+ PS=3.22U PD=3.22U
M$516 \$525 B|comp[41] GND GND nfet_03v3 L=0.28U W=1U AS=0.61P AD=0.61P
+ PS=3.22U PD=3.22U
M$517 \$527 B|comp[39] \$526 GND nfet_03v3 L=0.28U W=1U AS=0.61P AD=0.4P
+ PS=3.22U PD=1.8U
M$518 \$528 B|comp[40] \$527 GND nfet_03v3 L=0.28U W=1U AS=0.4P AD=0.4P PS=1.8U
+ PD=1.8U
M$519 GND \$525 \$528 GND nfet_03v3 L=0.28U W=1U AS=0.4P AD=0.61P PS=1.8U
+ PD=3.22U
M$520 GND \$526 out|wl[40] GND nfet_03v3 L=0.28U W=1U AS=0.61P AD=0.61P
+ PS=3.22U PD=3.22U
M$521 \$538 B|comp[42] GND GND nfet_03v3 L=0.28U W=1U AS=0.61P AD=0.61P
+ PS=3.22U PD=3.22U
M$522 \$546 B|comp[40] \$539 GND nfet_03v3 L=0.28U W=1U AS=0.61P AD=0.4P
+ PS=3.22U PD=1.8U
M$523 \$547 B|comp[41] \$546 GND nfet_03v3 L=0.28U W=1U AS=0.4P AD=0.4P PS=1.8U
+ PD=1.8U
M$524 GND \$538 \$547 GND nfet_03v3 L=0.28U W=1U AS=0.4P AD=0.61P PS=1.8U
+ PD=3.22U
M$525 GND \$539 out|wl[41] GND nfet_03v3 L=0.28U W=1U AS=0.61P AD=0.61P
+ PS=3.22U PD=3.22U
M$526 \$551 B|comp[43] GND GND nfet_03v3 L=0.28U W=1U AS=0.61P AD=0.61P
+ PS=3.22U PD=3.22U
M$527 \$553 B|comp[41] \$552 GND nfet_03v3 L=0.28U W=1U AS=0.61P AD=0.4P
+ PS=3.22U PD=1.8U
M$528 \$554 B|comp[42] \$553 GND nfet_03v3 L=0.28U W=1U AS=0.4P AD=0.4P PS=1.8U
+ PD=1.8U
M$529 GND \$551 \$554 GND nfet_03v3 L=0.28U W=1U AS=0.4P AD=0.61P PS=1.8U
+ PD=3.22U
M$530 GND \$552 out|wl[42] GND nfet_03v3 L=0.28U W=1U AS=0.61P AD=0.61P
+ PS=3.22U PD=3.22U
M$531 \$564 B|comp[44] GND GND nfet_03v3 L=0.28U W=1U AS=0.61P AD=0.61P
+ PS=3.22U PD=3.22U
M$532 \$572 B|comp[42] \$565 GND nfet_03v3 L=0.28U W=1U AS=0.61P AD=0.4P
+ PS=3.22U PD=1.8U
M$533 \$573 B|comp[43] \$572 GND nfet_03v3 L=0.28U W=1U AS=0.4P AD=0.4P PS=1.8U
+ PD=1.8U
M$534 GND \$564 \$573 GND nfet_03v3 L=0.28U W=1U AS=0.4P AD=0.61P PS=1.8U
+ PD=3.22U
M$535 GND \$565 out|wl[43] GND nfet_03v3 L=0.28U W=1U AS=0.61P AD=0.61P
+ PS=3.22U PD=3.22U
M$536 \$577 B|comp[45] GND GND nfet_03v3 L=0.28U W=1U AS=0.61P AD=0.61P
+ PS=3.22U PD=3.22U
M$537 \$579 B|comp[43] \$578 GND nfet_03v3 L=0.28U W=1U AS=0.61P AD=0.4P
+ PS=3.22U PD=1.8U
M$538 \$580 B|comp[44] \$579 GND nfet_03v3 L=0.28U W=1U AS=0.4P AD=0.4P PS=1.8U
+ PD=1.8U
M$539 GND \$577 \$580 GND nfet_03v3 L=0.28U W=1U AS=0.4P AD=0.61P PS=1.8U
+ PD=3.22U
M$540 GND \$578 out|wl[44] GND nfet_03v3 L=0.28U W=1U AS=0.61P AD=0.61P
+ PS=3.22U PD=3.22U
M$541 \$590 B|comp[46] GND GND nfet_03v3 L=0.28U W=1U AS=0.61P AD=0.61P
+ PS=3.22U PD=3.22U
M$542 \$598 B|comp[44] \$591 GND nfet_03v3 L=0.28U W=1U AS=0.61P AD=0.4P
+ PS=3.22U PD=1.8U
M$543 \$599 B|comp[45] \$598 GND nfet_03v3 L=0.28U W=1U AS=0.4P AD=0.4P PS=1.8U
+ PD=1.8U
M$544 GND \$590 \$599 GND nfet_03v3 L=0.28U W=1U AS=0.4P AD=0.61P PS=1.8U
+ PD=3.22U
M$545 GND \$591 out|wl[45] GND nfet_03v3 L=0.28U W=1U AS=0.61P AD=0.61P
+ PS=3.22U PD=3.22U
M$546 \$603 B|comp[47] GND GND nfet_03v3 L=0.28U W=1U AS=0.61P AD=0.61P
+ PS=3.22U PD=3.22U
M$547 \$605 B|comp[45] \$604 GND nfet_03v3 L=0.28U W=1U AS=0.61P AD=0.4P
+ PS=3.22U PD=1.8U
M$548 \$606 B|comp[46] \$605 GND nfet_03v3 L=0.28U W=1U AS=0.4P AD=0.4P PS=1.8U
+ PD=1.8U
M$549 GND \$603 \$606 GND nfet_03v3 L=0.28U W=1U AS=0.4P AD=0.61P PS=1.8U
+ PD=3.22U
M$550 GND \$604 out|wl[46] GND nfet_03v3 L=0.28U W=1U AS=0.61P AD=0.61P
+ PS=3.22U PD=3.22U
M$551 \$616 B|comp[48] GND GND nfet_03v3 L=0.28U W=1U AS=0.61P AD=0.61P
+ PS=3.22U PD=3.22U
M$552 \$624 B|comp[46] \$617 GND nfet_03v3 L=0.28U W=1U AS=0.61P AD=0.4P
+ PS=3.22U PD=1.8U
M$553 \$625 B|comp[47] \$624 GND nfet_03v3 L=0.28U W=1U AS=0.4P AD=0.4P PS=1.8U
+ PD=1.8U
M$554 GND \$616 \$625 GND nfet_03v3 L=0.28U W=1U AS=0.4P AD=0.61P PS=1.8U
+ PD=3.22U
M$555 GND \$617 out|wl[47] GND nfet_03v3 L=0.28U W=1U AS=0.61P AD=0.61P
+ PS=3.22U PD=3.22U
M$556 \$629 B|comp[49] GND GND nfet_03v3 L=0.28U W=1U AS=0.61P AD=0.61P
+ PS=3.22U PD=3.22U
M$557 \$631 B|comp[47] \$630 GND nfet_03v3 L=0.28U W=1U AS=0.61P AD=0.4P
+ PS=3.22U PD=1.8U
M$558 \$632 B|comp[48] \$631 GND nfet_03v3 L=0.28U W=1U AS=0.4P AD=0.4P PS=1.8U
+ PD=1.8U
M$559 GND \$629 \$632 GND nfet_03v3 L=0.28U W=1U AS=0.4P AD=0.61P PS=1.8U
+ PD=3.22U
M$560 GND \$630 out|wl[48] GND nfet_03v3 L=0.28U W=1U AS=0.61P AD=0.61P
+ PS=3.22U PD=3.22U
M$561 \$642 B|comp[50] GND GND nfet_03v3 L=0.28U W=1U AS=0.61P AD=0.61P
+ PS=3.22U PD=3.22U
M$562 \$650 B|comp[48] \$643 GND nfet_03v3 L=0.28U W=1U AS=0.61P AD=0.4P
+ PS=3.22U PD=1.8U
M$563 \$651 B|comp[49] \$650 GND nfet_03v3 L=0.28U W=1U AS=0.4P AD=0.4P PS=1.8U
+ PD=1.8U
M$564 GND \$642 \$651 GND nfet_03v3 L=0.28U W=1U AS=0.4P AD=0.61P PS=1.8U
+ PD=3.22U
M$565 GND \$643 out|wl[49] GND nfet_03v3 L=0.28U W=1U AS=0.61P AD=0.61P
+ PS=3.22U PD=3.22U
M$566 \$655 B|comp[51] GND GND nfet_03v3 L=0.28U W=1U AS=0.61P AD=0.61P
+ PS=3.22U PD=3.22U
M$567 \$657 B|comp[49] \$656 GND nfet_03v3 L=0.28U W=1U AS=0.61P AD=0.4P
+ PS=3.22U PD=1.8U
M$568 \$658 B|comp[50] \$657 GND nfet_03v3 L=0.28U W=1U AS=0.4P AD=0.4P PS=1.8U
+ PD=1.8U
M$569 GND \$655 \$658 GND nfet_03v3 L=0.28U W=1U AS=0.4P AD=0.61P PS=1.8U
+ PD=3.22U
M$570 GND \$656 out|wl[50] GND nfet_03v3 L=0.28U W=1U AS=0.61P AD=0.61P
+ PS=3.22U PD=3.22U
M$571 \$668 B|comp[52] GND GND nfet_03v3 L=0.28U W=1U AS=0.61P AD=0.61P
+ PS=3.22U PD=3.22U
M$572 \$676 B|comp[50] \$669 GND nfet_03v3 L=0.28U W=1U AS=0.61P AD=0.4P
+ PS=3.22U PD=1.8U
M$573 \$677 B|comp[51] \$676 GND nfet_03v3 L=0.28U W=1U AS=0.4P AD=0.4P PS=1.8U
+ PD=1.8U
M$574 GND \$668 \$677 GND nfet_03v3 L=0.28U W=1U AS=0.4P AD=0.61P PS=1.8U
+ PD=3.22U
M$575 GND \$669 out|wl[51] GND nfet_03v3 L=0.28U W=1U AS=0.61P AD=0.61P
+ PS=3.22U PD=3.22U
M$576 \$681 B|comp[53] GND GND nfet_03v3 L=0.28U W=1U AS=0.61P AD=0.61P
+ PS=3.22U PD=3.22U
M$577 \$683 B|comp[51] \$682 GND nfet_03v3 L=0.28U W=1U AS=0.61P AD=0.4P
+ PS=3.22U PD=1.8U
M$578 \$684 B|comp[52] \$683 GND nfet_03v3 L=0.28U W=1U AS=0.4P AD=0.4P PS=1.8U
+ PD=1.8U
M$579 GND \$681 \$684 GND nfet_03v3 L=0.28U W=1U AS=0.4P AD=0.61P PS=1.8U
+ PD=3.22U
M$580 GND \$682 out|wl[52] GND nfet_03v3 L=0.28U W=1U AS=0.61P AD=0.61P
+ PS=3.22U PD=3.22U
M$581 \$694 B|comp[54] GND GND nfet_03v3 L=0.28U W=1U AS=0.61P AD=0.61P
+ PS=3.22U PD=3.22U
M$582 \$702 B|comp[52] \$695 GND nfet_03v3 L=0.28U W=1U AS=0.61P AD=0.4P
+ PS=3.22U PD=1.8U
M$583 \$703 B|comp[53] \$702 GND nfet_03v3 L=0.28U W=1U AS=0.4P AD=0.4P PS=1.8U
+ PD=1.8U
M$584 GND \$694 \$703 GND nfet_03v3 L=0.28U W=1U AS=0.4P AD=0.61P PS=1.8U
+ PD=3.22U
M$585 GND \$695 out|wl[53] GND nfet_03v3 L=0.28U W=1U AS=0.61P AD=0.61P
+ PS=3.22U PD=3.22U
M$586 \$707 B|comp[55] GND GND nfet_03v3 L=0.28U W=1U AS=0.61P AD=0.61P
+ PS=3.22U PD=3.22U
M$587 \$709 B|comp[53] \$708 GND nfet_03v3 L=0.28U W=1U AS=0.61P AD=0.4P
+ PS=3.22U PD=1.8U
M$588 \$710 B|comp[54] \$709 GND nfet_03v3 L=0.28U W=1U AS=0.4P AD=0.4P PS=1.8U
+ PD=1.8U
M$589 GND \$707 \$710 GND nfet_03v3 L=0.28U W=1U AS=0.4P AD=0.61P PS=1.8U
+ PD=3.22U
M$590 GND \$708 out|wl[54] GND nfet_03v3 L=0.28U W=1U AS=0.61P AD=0.61P
+ PS=3.22U PD=3.22U
M$591 \$720 B|comp[56] GND GND nfet_03v3 L=0.28U W=1U AS=0.61P AD=0.61P
+ PS=3.22U PD=3.22U
M$592 \$728 B|comp[54] \$721 GND nfet_03v3 L=0.28U W=1U AS=0.61P AD=0.4P
+ PS=3.22U PD=1.8U
M$593 \$729 B|comp[55] \$728 GND nfet_03v3 L=0.28U W=1U AS=0.4P AD=0.4P PS=1.8U
+ PD=1.8U
M$594 GND \$720 \$729 GND nfet_03v3 L=0.28U W=1U AS=0.4P AD=0.61P PS=1.8U
+ PD=3.22U
M$595 GND \$721 out|wl[55] GND nfet_03v3 L=0.28U W=1U AS=0.61P AD=0.61P
+ PS=3.22U PD=3.22U
M$596 \$733 B|comp[57] GND GND nfet_03v3 L=0.28U W=1U AS=0.61P AD=0.61P
+ PS=3.22U PD=3.22U
M$597 \$735 B|comp[55] \$734 GND nfet_03v3 L=0.28U W=1U AS=0.61P AD=0.4P
+ PS=3.22U PD=1.8U
M$598 \$736 B|comp[56] \$735 GND nfet_03v3 L=0.28U W=1U AS=0.4P AD=0.4P PS=1.8U
+ PD=1.8U
M$599 GND \$733 \$736 GND nfet_03v3 L=0.28U W=1U AS=0.4P AD=0.61P PS=1.8U
+ PD=3.22U
M$600 GND \$734 out|wl[56] GND nfet_03v3 L=0.28U W=1U AS=0.61P AD=0.61P
+ PS=3.22U PD=3.22U
M$601 \$746 B|comp[58] GND GND nfet_03v3 L=0.28U W=1U AS=0.61P AD=0.61P
+ PS=3.22U PD=3.22U
M$602 \$754 B|comp[56] \$747 GND nfet_03v3 L=0.28U W=1U AS=0.61P AD=0.4P
+ PS=3.22U PD=1.8U
M$603 \$755 B|comp[57] \$754 GND nfet_03v3 L=0.28U W=1U AS=0.4P AD=0.4P PS=1.8U
+ PD=1.8U
M$604 GND \$746 \$755 GND nfet_03v3 L=0.28U W=1U AS=0.4P AD=0.61P PS=1.8U
+ PD=3.22U
M$605 GND \$747 out|wl[57] GND nfet_03v3 L=0.28U W=1U AS=0.61P AD=0.61P
+ PS=3.22U PD=3.22U
M$606 \$759 B|comp[59] GND GND nfet_03v3 L=0.28U W=1U AS=0.61P AD=0.61P
+ PS=3.22U PD=3.22U
M$607 \$761 B|comp[57] \$760 GND nfet_03v3 L=0.28U W=1U AS=0.61P AD=0.4P
+ PS=3.22U PD=1.8U
M$608 \$762 B|comp[58] \$761 GND nfet_03v3 L=0.28U W=1U AS=0.4P AD=0.4P PS=1.8U
+ PD=1.8U
M$609 GND \$759 \$762 GND nfet_03v3 L=0.28U W=1U AS=0.4P AD=0.61P PS=1.8U
+ PD=3.22U
M$610 GND \$760 out|wl[58] GND nfet_03v3 L=0.28U W=1U AS=0.61P AD=0.61P
+ PS=3.22U PD=3.22U
M$611 \$772 B|comp[60] GND GND nfet_03v3 L=0.28U W=1U AS=0.61P AD=0.61P
+ PS=3.22U PD=3.22U
M$612 \$780 B|comp[58] \$773 GND nfet_03v3 L=0.28U W=1U AS=0.61P AD=0.4P
+ PS=3.22U PD=1.8U
M$613 \$781 B|comp[59] \$780 GND nfet_03v3 L=0.28U W=1U AS=0.4P AD=0.4P PS=1.8U
+ PD=1.8U
M$614 GND \$772 \$781 GND nfet_03v3 L=0.28U W=1U AS=0.4P AD=0.61P PS=1.8U
+ PD=3.22U
M$615 GND \$773 out|wl[59] GND nfet_03v3 L=0.28U W=1U AS=0.61P AD=0.61P
+ PS=3.22U PD=3.22U
M$616 \$785 B|comp[61] GND GND nfet_03v3 L=0.28U W=1U AS=0.61P AD=0.61P
+ PS=3.22U PD=3.22U
M$617 \$787 B|comp[59] \$786 GND nfet_03v3 L=0.28U W=1U AS=0.61P AD=0.4P
+ PS=3.22U PD=1.8U
M$618 \$788 B|comp[60] \$787 GND nfet_03v3 L=0.28U W=1U AS=0.4P AD=0.4P PS=1.8U
+ PD=1.8U
M$619 GND \$785 \$788 GND nfet_03v3 L=0.28U W=1U AS=0.4P AD=0.61P PS=1.8U
+ PD=3.22U
M$620 GND \$786 out|wl[60] GND nfet_03v3 L=0.28U W=1U AS=0.61P AD=0.61P
+ PS=3.22U PD=3.22U
M$621 \$798 B|comp[62] GND GND nfet_03v3 L=0.28U W=1U AS=0.61P AD=0.61P
+ PS=3.22U PD=3.22U
M$622 \$806 B|comp[60] \$799 GND nfet_03v3 L=0.28U W=1U AS=0.61P AD=0.4P
+ PS=3.22U PD=1.8U
M$623 \$807 B|comp[61] \$806 GND nfet_03v3 L=0.28U W=1U AS=0.4P AD=0.4P PS=1.8U
+ PD=1.8U
M$624 GND \$798 \$807 GND nfet_03v3 L=0.28U W=1U AS=0.4P AD=0.61P PS=1.8U
+ PD=3.22U
M$625 GND \$799 out|wl[61] GND nfet_03v3 L=0.28U W=1U AS=0.61P AD=0.61P
+ PS=3.22U PD=3.22U
M$626 \$811 GND GND GND nfet_03v3 L=0.28U W=1U AS=0.61P AD=0.61P PS=3.22U
+ PD=3.22U
M$627 \$813 B|comp[61] \$812 GND nfet_03v3 L=0.28U W=1U AS=0.61P AD=0.4P
+ PS=3.22U PD=1.8U
M$628 \$814 B|comp[62] \$813 GND nfet_03v3 L=0.28U W=1U AS=0.4P AD=0.4P PS=1.8U
+ PD=1.8U
M$629 GND \$811 \$814 GND nfet_03v3 L=0.28U W=1U AS=0.4P AD=0.61P PS=1.8U
+ PD=3.22U
M$630 GND \$812 out|wl[62] GND nfet_03v3 L=0.28U W=1U AS=0.61P AD=0.61P
+ PS=3.22U PD=3.22U
.ENDS tm_to_bin2
