* Extracted by KLayout with GF180MCU LVS runset on : 13/07/2026 23:49

* cell rom2
* pin B0
* pin B1
* pin B2
* pin B3
* pin B4
* pin GND
* pin IN0
* pin IN1
* pin IN10
* pin IN11
* pin IN12
* pin IN13
* pin IN14
* pin IN15
* pin IN16
* pin IN17
* pin IN18
* pin IN19
* pin IN2
* pin IN20
* pin IN21
* pin IN22
* pin IN23
* pin IN24
* pin IN25
* pin IN26
* pin IN27
* pin IN28
* pin IN29
* pin IN3
* pin IN30
* pin IN32
* pin IN33
* pin IN34
* pin IN35
* pin IN36
* pin IN37
* pin IN38
* pin IN39
* pin IN4
* pin IN40
* pin IN41
* pin IN42
* pin IN43
* pin IN44
* pin IN45
* pin IN46
* pin IN47
* pin IN48
* pin IN49
* pin IN5
* pin IN50
* pin IN51
* pin IN52
* pin IN53
* pin IN54
* pin IN55
* pin IN56
* pin IN57
* pin IN58
* pin IN59
* pin IN6
* pin IN60
* pin IN61
* pin IN62
* pin IN7
* pin IN8
* pin IN9
* pin THERMOMETER_31
* pin VDD
.SUBCKT rom2 B0 B1 B2 B3 B4 GND IN0 IN1 IN10 IN11 IN12 IN13 IN14 IN15 IN16 IN17
+ IN18 IN19 IN2 IN20 IN21 IN22 IN23 IN24 IN25 IN26 IN27 IN28 IN29 IN3 IN30 IN32
+ IN33 IN34 IN35 IN36 IN37 IN38 IN39 IN4 IN40 IN41 IN42 IN43 IN44 IN45 IN46
+ IN47 IN48 IN49 IN5 IN50 IN51 IN52 IN53 IN54 IN55 IN56 IN57 IN58 IN59 IN6 IN60
+ IN61 IN62 IN7 IN8 IN9 THERMOMETER_31 VDD
* device instance $1 r0 *1 61.15,63.98 pfet_03v3
M$1 VDD VDD VDD VDD pfet_03v3 L=0.28U W=1.32U AS=0.5148P AD=0.5148P PS=4.1U
+ PD=4.1U
* device instance $4 r0 *1 61.14,68.24 nfet_03v3
M$4 GND GND GND GND nfet_03v3 L=0.28U W=0.44U AS=0.2684P AD=0.2684P PS=2.1U
+ PD=2.1U
* device instance $5 r0 *1 60.73,82.5 nfet_03v3
M$5 \$I2596 \$I2595 \$I2597 GND nfet_03v3 L=0.28U W=0.44U AS=0.2684P AD=0.2684P
+ PS=2.1U PD=2.1U
* device instance $6 m90 *1 77.45,82.5 nfet_03v3
M$6 \$I2600 \$I2599 \$I2601 GND nfet_03v3 L=0.28U W=0.44U AS=0.2684P AD=0.2684P
+ PS=2.1U PD=2.1U
* device instance $7 m90 *1 72.71,82.5 nfet_03v3
M$7 \$I2604 \$I2603 \$I2605 GND nfet_03v3 L=0.28U W=0.44U AS=0.2684P AD=0.2684P
+ PS=2.1U PD=2.1U
* device instance $8 m90 *1 63.23,82.5 nfet_03v3
M$8 \$I2608 \$I2607 \$I2609 GND nfet_03v3 L=0.28U W=0.44U AS=0.2684P AD=0.2684P
+ PS=2.1U PD=2.1U
* device instance $9 m90 *1 86.93,82.5 nfet_03v3
M$9 \$I2612 \$I2611 \$I2613 GND nfet_03v3 L=0.28U W=0.44U AS=0.2684P AD=0.2684P
+ PS=2.1U PD=2.1U
* device instance $10 m90 *1 67.97,82.5 nfet_03v3
M$10 \$I2616 \$I2615 \$I2617 GND nfet_03v3 L=0.28U W=0.44U AS=0.2684P
+ AD=0.2684P PS=2.1U PD=2.1U
* device instance $11 m90 *1 82.19,82.5 nfet_03v3
M$11 \$I2620 \$I2619 \$I2621 GND nfet_03v3 L=0.28U W=0.44U AS=0.2684P
+ AD=0.2684P PS=2.1U PD=2.1U
* device instance $12 r0 *1 79.69,82.5 nfet_03v3
M$12 \$I2624 \$I2623 \$I2625 GND nfet_03v3 L=0.28U W=0.44U AS=0.2684P
+ AD=0.2684P PS=2.1U PD=2.1U
* device instance $13 r0 *1 70.21,82.5 nfet_03v3
M$13 \$I2628 \$I2627 \$I2629 GND nfet_03v3 L=0.28U W=0.44U AS=0.2684P
+ AD=0.2684P PS=2.1U PD=2.1U
* device instance $14 r0 *1 74.95,82.5 nfet_03v3
M$14 \$I2632 \$I2631 \$I2633 GND nfet_03v3 L=0.28U W=0.44U AS=0.2684P
+ AD=0.2684P PS=2.1U PD=2.1U
* device instance $15 r0 *1 65.47,82.5 nfet_03v3
M$15 \$I2636 \$I2635 \$I2637 GND nfet_03v3 L=0.28U W=0.44U AS=0.2684P
+ AD=0.2684P PS=2.1U PD=2.1U
* device instance $16 r0 *1 84.43,82.5 nfet_03v3
M$16 \$I2640 \$I2639 \$I2641 GND nfet_03v3 L=0.28U W=0.44U AS=0.2684P
+ AD=0.2684P PS=2.1U PD=2.1U
* device instance $17 r0 *1 70.21,107.1 nfet_03v3
M$17 \$I2644 \$I2643 \$I2645 GND nfet_03v3 L=0.28U W=0.44U AS=0.2684P
+ AD=0.2684P PS=2.1U PD=2.1U
* device instance $18 r0 *1 70.21,102.18 nfet_03v3
M$18 \$I2647 \$I2646 \$I2648 GND nfet_03v3 L=0.28U W=0.44U AS=0.2684P
+ AD=0.2684P PS=2.1U PD=2.1U
* device instance $19 r0 *1 70.21,95.62 nfet_03v3
M$19 \$I2650 \$I2649 \$I2651 GND nfet_03v3 L=0.28U W=0.44U AS=0.2684P
+ AD=0.2684P PS=2.1U PD=2.1U
* device instance $20 r0 *1 70.21,87.42 nfet_03v3
M$20 \$I2653 \$I2652 \$I2654 GND nfet_03v3 L=0.28U W=0.44U AS=0.2684P
+ AD=0.2684P PS=2.1U PD=2.1U
* device instance $21 r0 *1 70.21,89.06 nfet_03v3
M$21 \$I2656 \$I2655 \$I2657 GND nfet_03v3 L=0.28U W=0.44U AS=0.2684P
+ AD=0.2684P PS=2.1U PD=2.1U
* device instance $22 r0 *1 70.21,93.98 nfet_03v3
M$22 \$I2659 \$I2658 \$I2660 GND nfet_03v3 L=0.28U W=0.44U AS=0.2684P
+ AD=0.2684P PS=2.1U PD=2.1U
* device instance $23 r0 *1 70.21,100.54 nfet_03v3
M$23 \$I2662 \$I2661 \$I2663 GND nfet_03v3 L=0.28U W=0.44U AS=0.2684P
+ AD=0.2684P PS=2.1U PD=2.1U
* device instance $24 r0 *1 70.21,113.66 nfet_03v3
M$24 \$I2665 \$I2664 \$I2666 GND nfet_03v3 L=0.28U W=0.44U AS=0.2684P
+ AD=0.2684P PS=2.1U PD=2.1U
* device instance $25 r0 *1 70.21,115.3 nfet_03v3
M$25 \$I2668 \$I2667 \$I2669 GND nfet_03v3 L=0.28U W=0.44U AS=0.2684P
+ AD=0.2684P PS=2.1U PD=2.1U
* device instance $26 r0 *1 70.21,133.34 nfet_03v3
M$26 \$I2671 \$I2670 \$I2672 GND nfet_03v3 L=0.28U W=0.44U AS=0.2684P
+ AD=0.2684P PS=2.1U PD=2.1U
* device instance $27 r0 *1 70.21,128.42 nfet_03v3
M$27 \$I2674 \$I2673 \$I2675 GND nfet_03v3 L=0.28U W=0.44U AS=0.2684P
+ AD=0.2684P PS=2.1U PD=2.1U
* device instance $28 r0 *1 70.21,126.78 nfet_03v3
M$28 \$I2677 \$I2676 \$I2678 GND nfet_03v3 L=0.28U W=0.44U AS=0.2684P
+ AD=0.2684P PS=2.1U PD=2.1U
* device instance $29 r0 *1 70.21,121.86 nfet_03v3
M$29 \$I2680 \$I2679 \$I2681 GND nfet_03v3 L=0.28U W=0.44U AS=0.2684P
+ AD=0.2684P PS=2.1U PD=2.1U
* device instance $30 r0 *1 70.21,120.22 nfet_03v3
M$30 \$I2683 \$I2682 \$I2684 GND nfet_03v3 L=0.28U W=0.44U AS=0.2684P
+ AD=0.2684P PS=2.1U PD=2.1U
* device instance $31 r0 *1 70.21,108.74 nfet_03v3
M$31 \$I2686 \$I2685 \$I2687 GND nfet_03v3 L=0.28U W=0.44U AS=0.2684P
+ AD=0.2684P PS=2.1U PD=2.1U
* device instance $32 m90 *1 82.19,133.34 nfet_03v3
M$32 \$I2689 \$I2688 \$I2690 GND nfet_03v3 L=0.28U W=0.44U AS=0.2684P
+ AD=0.2684P PS=2.1U PD=2.1U
* device instance $33 m90 *1 82.19,121.86 nfet_03v3
M$33 \$I2692 \$I2691 \$I2693 GND nfet_03v3 L=0.28U W=0.44U AS=0.2684P
+ AD=0.2684P PS=2.1U PD=2.1U
* device instance $34 m90 *1 82.19,100.54 nfet_03v3
M$34 \$I2695 \$I2694 \$I2696 GND nfet_03v3 L=0.28U W=0.44U AS=0.2684P
+ AD=0.2684P PS=2.1U PD=2.1U
* device instance $35 m90 *1 82.19,126.78 nfet_03v3
M$35 \$I2698 \$I2697 \$I2699 GND nfet_03v3 L=0.28U W=0.44U AS=0.2684P
+ AD=0.2684P PS=2.1U PD=2.1U
* device instance $36 m90 *1 82.19,128.42 nfet_03v3
M$36 \$I2701 \$I2700 \$I2702 GND nfet_03v3 L=0.28U W=0.44U AS=0.2684P
+ AD=0.2684P PS=2.1U PD=2.1U
* device instance $37 m90 *1 82.19,107.1 nfet_03v3
M$37 \$I2704 \$I2703 \$I2705 GND nfet_03v3 L=0.28U W=0.44U AS=0.2684P
+ AD=0.2684P PS=2.1U PD=2.1U
* device instance $38 m90 *1 82.19,89.06 nfet_03v3
M$38 \$I2707 \$I2706 \$I2708 GND nfet_03v3 L=0.28U W=0.44U AS=0.2684P
+ AD=0.2684P PS=2.1U PD=2.1U
* device instance $39 m90 *1 82.19,87.42 nfet_03v3
M$39 \$I2710 \$I2709 \$I2711 GND nfet_03v3 L=0.28U W=0.44U AS=0.2684P
+ AD=0.2684P PS=2.1U PD=2.1U
* device instance $40 m90 *1 82.19,93.98 nfet_03v3
M$40 \$I2713 \$I2712 \$I2714 GND nfet_03v3 L=0.28U W=0.44U AS=0.2684P
+ AD=0.2684P PS=2.1U PD=2.1U
* device instance $41 m90 *1 82.19,102.18 nfet_03v3
M$41 \$I2716 \$I2715 \$I2717 GND nfet_03v3 L=0.28U W=0.44U AS=0.2684P
+ AD=0.2684P PS=2.1U PD=2.1U
* device instance $42 m90 *1 82.19,113.66 nfet_03v3
M$42 \$I2719 \$I2718 \$I2720 GND nfet_03v3 L=0.28U W=0.44U AS=0.2684P
+ AD=0.2684P PS=2.1U PD=2.1U
* device instance $43 m90 *1 82.19,120.22 nfet_03v3
M$43 \$I2722 \$I2721 \$I2723 GND nfet_03v3 L=0.28U W=0.44U AS=0.2684P
+ AD=0.2684P PS=2.1U PD=2.1U
* device instance $44 m90 *1 82.19,115.3 nfet_03v3
M$44 \$I2725 \$I2724 \$I2726 GND nfet_03v3 L=0.28U W=0.44U AS=0.2684P
+ AD=0.2684P PS=2.1U PD=2.1U
* device instance $45 m90 *1 82.19,95.62 nfet_03v3
M$45 \$I2728 \$I2727 \$I2729 GND nfet_03v3 L=0.28U W=0.44U AS=0.2684P
+ AD=0.2684P PS=2.1U PD=2.1U
* device instance $46 m90 *1 82.19,108.74 nfet_03v3
M$46 \$I2731 \$I2730 \$I2732 GND nfet_03v3 L=0.28U W=0.44U AS=0.2684P
+ AD=0.2684P PS=2.1U PD=2.1U
* device instance $47 r0 *1 65.47,105.46 nfet_03v3
M$47 \$I2734 \$I2733 \$I2735 GND nfet_03v3 L=0.28U W=0.44U AS=0.2684P
+ AD=0.2684P PS=2.1U PD=2.1U
* device instance $48 r0 *1 65.47,125.14 nfet_03v3
M$48 \$I2737 \$I2736 \$I2738 GND nfet_03v3 L=0.28U W=0.44U AS=0.2684P
+ AD=0.2684P PS=2.1U PD=2.1U
* device instance $49 r0 *1 65.47,131.7 nfet_03v3
M$49 \$I2740 \$I2739 \$I2741 GND nfet_03v3 L=0.28U W=0.44U AS=0.2684P
+ AD=0.2684P PS=2.1U PD=2.1U
* device instance $50 r0 *1 65.47,130.06 nfet_03v3
M$50 \$I2743 \$I2742 \$I2744 GND nfet_03v3 L=0.28U W=0.44U AS=0.2684P
+ AD=0.2684P PS=2.1U PD=2.1U
* device instance $51 r0 *1 65.47,97.26 nfet_03v3
M$51 \$I2746 \$I2745 \$I2747 GND nfet_03v3 L=0.28U W=0.44U AS=0.2684P
+ AD=0.2684P PS=2.1U PD=2.1U
* device instance $52 r0 *1 65.47,98.9 nfet_03v3
M$52 \$I2749 \$I2748 \$I2750 GND nfet_03v3 L=0.28U W=0.44U AS=0.2684P
+ AD=0.2684P PS=2.1U PD=2.1U
* device instance $53 r0 *1 65.47,103.82 nfet_03v3
M$53 \$I2752 \$I2751 \$I2753 GND nfet_03v3 L=0.28U W=0.44U AS=0.2684P
+ AD=0.2684P PS=2.1U PD=2.1U
* device instance $54 r0 *1 65.47,102.18 nfet_03v3
M$54 \$I2755 \$I2754 \$I2756 GND nfet_03v3 L=0.28U W=0.44U AS=0.2684P
+ AD=0.2684P PS=2.1U PD=2.1U
* device instance $55 r0 *1 65.47,107.1 nfet_03v3
M$55 \$I2758 \$I2757 \$I2759 GND nfet_03v3 L=0.28U W=0.44U AS=0.2684P
+ AD=0.2684P PS=2.1U PD=2.1U
* device instance $56 r0 *1 65.47,126.78 nfet_03v3
M$56 \$I2761 \$I2760 \$I2762 GND nfet_03v3 L=0.28U W=0.44U AS=0.2684P
+ AD=0.2684P PS=2.1U PD=2.1U
* device instance $57 r0 *1 65.47,100.54 nfet_03v3
M$57 \$I2764 \$I2763 \$I2765 GND nfet_03v3 L=0.28U W=0.44U AS=0.2684P
+ AD=0.2684P PS=2.1U PD=2.1U
* device instance $58 r0 *1 65.47,133.34 nfet_03v3
M$58 \$I2767 \$I2766 \$I2768 GND nfet_03v3 L=0.28U W=0.44U AS=0.2684P
+ AD=0.2684P PS=2.1U PD=2.1U
* device instance $59 r0 *1 65.47,128.42 nfet_03v3
M$59 \$I2770 \$I2769 \$I2771 GND nfet_03v3 L=0.28U W=0.44U AS=0.2684P
+ AD=0.2684P PS=2.1U PD=2.1U
* device instance $60 r0 *1 65.47,123.5 nfet_03v3
M$60 \$I2773 \$I2772 \$I2774 GND nfet_03v3 L=0.28U W=0.44U AS=0.2684P
+ AD=0.2684P PS=2.1U PD=2.1U
* device instance $61 r0 *1 65.47,108.74 nfet_03v3
M$61 \$I2776 \$I2775 \$I2777 GND nfet_03v3 L=0.28U W=0.44U AS=0.2684P
+ AD=0.2684P PS=2.1U PD=2.1U
* device instance $62 m90 *1 77.45,123.5 nfet_03v3
M$62 \$I2779 \$I2778 \$I2780 GND nfet_03v3 L=0.28U W=0.44U AS=0.2684P
+ AD=0.2684P PS=2.1U PD=2.1U
* device instance $63 m90 *1 77.45,133.34 nfet_03v3
M$63 \$I2782 \$I2781 \$I2783 GND nfet_03v3 L=0.28U W=0.44U AS=0.2684P
+ AD=0.2684P PS=2.1U PD=2.1U
* device instance $64 m90 *1 77.45,126.78 nfet_03v3
M$64 \$I2785 \$I2784 \$I2786 GND nfet_03v3 L=0.28U W=0.44U AS=0.2684P
+ AD=0.2684P PS=2.1U PD=2.1U
* device instance $65 m90 *1 77.45,130.06 nfet_03v3
M$65 \$I2788 \$I2787 \$I2789 GND nfet_03v3 L=0.28U W=0.44U AS=0.2684P
+ AD=0.2684P PS=2.1U PD=2.1U
* device instance $66 m90 *1 77.45,131.7 nfet_03v3
M$66 \$I2791 \$I2790 \$I2792 GND nfet_03v3 L=0.28U W=0.44U AS=0.2684P
+ AD=0.2684P PS=2.1U PD=2.1U
* device instance $67 m90 *1 77.45,128.42 nfet_03v3
M$67 \$I2794 \$I2793 \$I2795 GND nfet_03v3 L=0.28U W=0.44U AS=0.2684P
+ AD=0.2684P PS=2.1U PD=2.1U
* device instance $68 m90 *1 77.45,125.14 nfet_03v3
M$68 \$I2797 \$I2796 \$I2798 GND nfet_03v3 L=0.28U W=0.44U AS=0.2684P
+ AD=0.2684P PS=2.1U PD=2.1U
* device instance $69 m90 *1 77.45,102.18 nfet_03v3
M$69 \$I2800 \$I2799 \$I2801 GND nfet_03v3 L=0.28U W=0.44U AS=0.2684P
+ AD=0.2684P PS=2.1U PD=2.1U
* device instance $70 m90 *1 77.45,98.9 nfet_03v3
M$70 \$I2803 \$I2802 \$I2804 GND nfet_03v3 L=0.28U W=0.44U AS=0.2684P
+ AD=0.2684P PS=2.1U PD=2.1U
* device instance $71 m90 *1 77.45,97.26 nfet_03v3
M$71 \$I2806 \$I2805 \$I2807 GND nfet_03v3 L=0.28U W=0.44U AS=0.2684P
+ AD=0.2684P PS=2.1U PD=2.1U
* device instance $72 m90 *1 77.45,100.54 nfet_03v3
M$72 \$I2809 \$I2808 \$I2810 GND nfet_03v3 L=0.28U W=0.44U AS=0.2684P
+ AD=0.2684P PS=2.1U PD=2.1U
* device instance $73 m90 *1 77.45,103.82 nfet_03v3
M$73 \$I2812 \$I2811 \$I2813 GND nfet_03v3 L=0.28U W=0.44U AS=0.2684P
+ AD=0.2684P PS=2.1U PD=2.1U
* device instance $74 m90 *1 77.45,105.46 nfet_03v3
M$74 \$I2815 \$I2814 \$I2816 GND nfet_03v3 L=0.28U W=0.44U AS=0.2684P
+ AD=0.2684P PS=2.1U PD=2.1U
* device instance $75 m90 *1 77.45,107.1 nfet_03v3
M$75 \$I2818 \$I2817 \$I2819 GND nfet_03v3 L=0.28U W=0.44U AS=0.2684P
+ AD=0.2684P PS=2.1U PD=2.1U
* device instance $76 m90 *1 77.45,108.74 nfet_03v3
M$76 \$I2821 \$I2820 \$I2822 GND nfet_03v3 L=0.28U W=0.44U AS=0.2684P
+ AD=0.2684P PS=2.1U PD=2.1U
* device instance $77 r0 *1 60.73,84.14 nfet_03v3
M$77 \$I2824 \$I2823 \$I2825 GND nfet_03v3 L=0.28U W=0.44U AS=0.2684P
+ AD=0.2684P PS=2.1U PD=2.1U
* device instance $78 m90 *1 86.93,84.14 nfet_03v3
M$78 \$I2827 \$I2826 \$I2828 GND nfet_03v3 L=0.28U W=0.44U AS=0.2684P
+ AD=0.2684P PS=2.1U PD=2.1U
* device instance $79 m90 *1 63.23,128.42 nfet_03v3
M$79 \$I2830 \$I2829 \$I2831 GND nfet_03v3 L=0.28U W=0.44U AS=0.2684P
+ AD=0.2684P PS=2.1U PD=2.1U
* device instance $80 m90 *1 63.23,131.7 nfet_03v3
M$80 \$I2833 \$I2832 \$I2834 GND nfet_03v3 L=0.28U W=0.44U AS=0.2684P
+ AD=0.2684P PS=2.1U PD=2.1U
* device instance $81 m90 *1 63.23,120.22 nfet_03v3
M$81 \$I2836 \$I2835 \$I2837 GND nfet_03v3 L=0.28U W=0.44U AS=0.2684P
+ AD=0.2684P PS=2.1U PD=2.1U
* device instance $82 m90 *1 63.23,123.5 nfet_03v3
M$82 \$I2839 \$I2838 \$I2840 GND nfet_03v3 L=0.28U W=0.44U AS=0.2684P
+ AD=0.2684P PS=2.1U PD=2.1U
* device instance $83 m90 *1 63.23,125.14 nfet_03v3
M$83 \$I2842 \$I2841 \$I2843 GND nfet_03v3 L=0.28U W=0.44U AS=0.2684P
+ AD=0.2684P PS=2.1U PD=2.1U
* device instance $84 m90 *1 63.23,126.78 nfet_03v3
M$84 \$I2845 \$I2844 \$I2846 GND nfet_03v3 L=0.28U W=0.44U AS=0.2684P
+ AD=0.2684P PS=2.1U PD=2.1U
* device instance $85 m90 *1 63.23,133.34 nfet_03v3
M$85 \$I2848 \$I2847 \$I2849 GND nfet_03v3 L=0.28U W=0.44U AS=0.2684P
+ AD=0.2684P PS=2.1U PD=2.1U
* device instance $86 m90 *1 63.23,115.3 nfet_03v3
M$86 \$I2851 \$I2850 \$I2852 GND nfet_03v3 L=0.28U W=0.44U AS=0.2684P
+ AD=0.2684P PS=2.1U PD=2.1U
* device instance $87 m90 *1 63.23,121.86 nfet_03v3
M$87 \$I2854 \$I2853 \$I2855 GND nfet_03v3 L=0.28U W=0.44U AS=0.2684P
+ AD=0.2684P PS=2.1U PD=2.1U
* device instance $88 m90 *1 63.23,113.66 nfet_03v3
M$88 \$I2857 \$I2856 \$I2858 GND nfet_03v3 L=0.28U W=0.44U AS=0.2684P
+ AD=0.2684P PS=2.1U PD=2.1U
* device instance $89 m90 *1 63.23,118.58 nfet_03v3
M$89 \$I2860 \$I2859 \$I2861 GND nfet_03v3 L=0.28U W=0.44U AS=0.2684P
+ AD=0.2684P PS=2.1U PD=2.1U
* device instance $90 m90 *1 63.23,130.06 nfet_03v3
M$90 \$I2863 \$I2862 \$I2864 GND nfet_03v3 L=0.28U W=0.44U AS=0.2684P
+ AD=0.2684P PS=2.1U PD=2.1U
* device instance $91 m90 *1 63.23,116.94 nfet_03v3
M$91 \$I2866 \$I2865 \$I2867 GND nfet_03v3 L=0.28U W=0.44U AS=0.2684P
+ AD=0.2684P PS=2.1U PD=2.1U
* device instance $92 m90 *1 63.23,112.02 nfet_03v3
M$92 \$I2869 \$I2868 \$I2870 GND nfet_03v3 L=0.28U W=0.44U AS=0.2684P
+ AD=0.2684P PS=2.1U PD=2.1U
* device instance $93 m90 *1 63.23,110.38 nfet_03v3
M$93 \$I2872 \$I2871 \$I2873 GND nfet_03v3 L=0.28U W=0.44U AS=0.2684P
+ AD=0.2684P PS=2.1U PD=2.1U
* device instance $94 r0 *1 74.95,131.7 nfet_03v3
M$94 \$I2875 \$I2874 \$I2876 GND nfet_03v3 L=0.28U W=0.44U AS=0.2684P
+ AD=0.2684P PS=2.1U PD=2.1U
* device instance $95 r0 *1 74.95,126.78 nfet_03v3
M$95 \$I2878 \$I2877 \$I2879 GND nfet_03v3 L=0.28U W=0.44U AS=0.2684P
+ AD=0.2684P PS=2.1U PD=2.1U
* device instance $96 r0 *1 74.95,116.94 nfet_03v3
M$96 \$I2881 \$I2880 \$I2882 GND nfet_03v3 L=0.28U W=0.44U AS=0.2684P
+ AD=0.2684P PS=2.1U PD=2.1U
* device instance $97 r0 *1 74.95,112.02 nfet_03v3
M$97 \$I2884 \$I2883 \$I2885 GND nfet_03v3 L=0.28U W=0.44U AS=0.2684P
+ AD=0.2684P PS=2.1U PD=2.1U
* device instance $98 r0 *1 74.95,110.38 nfet_03v3
M$98 \$I2887 \$I2886 \$I2888 GND nfet_03v3 L=0.28U W=0.44U AS=0.2684P
+ AD=0.2684P PS=2.1U PD=2.1U
* device instance $99 r0 *1 74.95,118.58 nfet_03v3
M$99 \$I2890 \$I2889 \$I2891 GND nfet_03v3 L=0.28U W=0.44U AS=0.2684P
+ AD=0.2684P PS=2.1U PD=2.1U
* device instance $100 r0 *1 74.95,115.3 nfet_03v3
M$100 \$I2893 \$I2892 \$I2894 GND nfet_03v3 L=0.28U W=0.44U AS=0.2684P
+ AD=0.2684P PS=2.1U PD=2.1U
* device instance $101 r0 *1 74.95,113.66 nfet_03v3
M$101 \$I2896 \$I2895 \$I2897 GND nfet_03v3 L=0.28U W=0.44U AS=0.2684P
+ AD=0.2684P PS=2.1U PD=2.1U
* device instance $102 r0 *1 74.95,125.14 nfet_03v3
M$102 \$I2899 \$I2898 \$I2900 GND nfet_03v3 L=0.28U W=0.44U AS=0.2684P
+ AD=0.2684P PS=2.1U PD=2.1U
* device instance $103 r0 *1 74.95,123.5 nfet_03v3
M$103 \$I2902 \$I2901 \$I2903 GND nfet_03v3 L=0.28U W=0.44U AS=0.2684P
+ AD=0.2684P PS=2.1U PD=2.1U
* device instance $104 r0 *1 74.95,121.86 nfet_03v3
M$104 \$I2905 \$I2904 \$I2906 GND nfet_03v3 L=0.28U W=0.44U AS=0.2684P
+ AD=0.2684P PS=2.1U PD=2.1U
* device instance $105 r0 *1 74.95,120.22 nfet_03v3
M$105 \$I2908 \$I2907 \$I2909 GND nfet_03v3 L=0.28U W=0.44U AS=0.2684P
+ AD=0.2684P PS=2.1U PD=2.1U
* device instance $106 r0 *1 74.95,130.06 nfet_03v3
M$106 \$I2911 \$I2910 \$I2912 GND nfet_03v3 L=0.28U W=0.44U AS=0.2684P
+ AD=0.2684P PS=2.1U PD=2.1U
* device instance $107 r0 *1 74.95,128.42 nfet_03v3
M$107 \$I2914 \$I2913 \$I2915 GND nfet_03v3 L=0.28U W=0.44U AS=0.2684P
+ AD=0.2684P PS=2.1U PD=2.1U
* device instance $108 r0 *1 74.95,133.34 nfet_03v3
M$108 \$I2917 \$I2916 \$I2918 GND nfet_03v3 L=0.28U W=0.44U AS=0.2684P
+ AD=0.2684P PS=2.1U PD=2.1U
* device instance $109 r0 *1 60.73,87.42 nfet_03v3
M$109 \$I2920 \$I2919 \$I2921 GND nfet_03v3 L=0.28U W=0.44U AS=0.2684P
+ AD=0.2684P PS=2.1U PD=2.1U
* device instance $110 r0 *1 60.73,85.78 nfet_03v3
M$110 \$I2923 \$I2922 \$I2924 GND nfet_03v3 L=0.28U W=0.44U AS=0.2684P
+ AD=0.2684P PS=2.1U PD=2.1U
* device instance $111 m90 *1 72.71,85.78 nfet_03v3
M$111 \$I2926 \$I2925 \$I2927 GND nfet_03v3 L=0.28U W=0.44U AS=0.2684P
+ AD=0.2684P PS=2.1U PD=2.1U
* device instance $112 m90 *1 86.93,87.42 nfet_03v3
M$112 \$I2929 \$I2928 \$I2930 GND nfet_03v3 L=0.28U W=0.44U AS=0.2684P
+ AD=0.2684P PS=2.1U PD=2.1U
* device instance $113 m90 *1 86.93,85.78 nfet_03v3
M$113 \$I2932 \$I2931 \$I2933 GND nfet_03v3 L=0.28U W=0.44U AS=0.2684P
+ AD=0.2684P PS=2.1U PD=2.1U
* device instance $114 r0 *1 84.43,85.78 nfet_03v3
M$114 \$I2935 \$I2934 \$I2936 GND nfet_03v3 L=0.28U W=0.44U AS=0.2684P
+ AD=0.2684P PS=2.1U PD=2.1U
* device instance $115 m90 *1 67.97,133.34 nfet_03v3
M$115 \$I2938 \$I2937 \$I2939 GND nfet_03v3 L=0.28U W=0.44U AS=0.2684P
+ AD=0.2684P PS=2.1U PD=2.1U
* device instance $116 m90 *1 67.97,121.86 nfet_03v3
M$116 \$I2941 \$I2940 \$I2942 GND nfet_03v3 L=0.28U W=0.44U AS=0.2684P
+ AD=0.2684P PS=2.1U PD=2.1U
* device instance $117 m90 *1 67.97,120.22 nfet_03v3
M$117 \$I2944 \$I2943 \$I2945 GND nfet_03v3 L=0.28U W=0.44U AS=0.2684P
+ AD=0.2684P PS=2.1U PD=2.1U
* device instance $118 m90 *1 67.97,116.94 nfet_03v3
M$118 \$I2947 \$I2946 \$I2948 GND nfet_03v3 L=0.28U W=0.44U AS=0.2684P
+ AD=0.2684P PS=2.1U PD=2.1U
* device instance $119 m90 *1 67.97,130.06 nfet_03v3
M$119 \$I2950 \$I2949 \$I2951 GND nfet_03v3 L=0.28U W=0.44U AS=0.2684P
+ AD=0.2684P PS=2.1U PD=2.1U
* device instance $120 m90 *1 67.97,92.34 nfet_03v3
M$120 \$I2953 \$I2952 \$I2954 GND nfet_03v3 L=0.28U W=0.44U AS=0.2684P
+ AD=0.2684P PS=2.1U PD=2.1U
* device instance $121 m90 *1 67.97,108.74 nfet_03v3
M$121 \$I2956 \$I2955 \$I2957 GND nfet_03v3 L=0.28U W=0.44U AS=0.2684P
+ AD=0.2684P PS=2.1U PD=2.1U
* device instance $122 m90 *1 67.97,131.7 nfet_03v3
M$122 \$I2959 \$I2958 \$I2960 GND nfet_03v3 L=0.28U W=0.44U AS=0.2684P
+ AD=0.2684P PS=2.1U PD=2.1U
* device instance $123 m90 *1 67.97,90.7 nfet_03v3
M$123 \$I2962 \$I2961 \$I2963 GND nfet_03v3 L=0.28U W=0.44U AS=0.2684P
+ AD=0.2684P PS=2.1U PD=2.1U
* device instance $124 m90 *1 67.97,107.1 nfet_03v3
M$124 \$I2965 \$I2964 \$I2966 GND nfet_03v3 L=0.28U W=0.44U AS=0.2684P
+ AD=0.2684P PS=2.1U PD=2.1U
* device instance $125 m90 *1 67.97,105.46 nfet_03v3
M$125 \$I2968 \$I2967 \$I2969 GND nfet_03v3 L=0.28U W=0.44U AS=0.2684P
+ AD=0.2684P PS=2.1U PD=2.1U
* device instance $126 m90 *1 67.97,93.98 nfet_03v3
M$126 \$I2971 \$I2970 \$I2972 GND nfet_03v3 L=0.28U W=0.44U AS=0.2684P
+ AD=0.2684P PS=2.1U PD=2.1U
* device instance $127 m90 *1 67.97,103.82 nfet_03v3
M$127 \$I2974 \$I2973 \$I2975 GND nfet_03v3 L=0.28U W=0.44U AS=0.2684P
+ AD=0.2684P PS=2.1U PD=2.1U
* device instance $128 m90 *1 67.97,95.62 nfet_03v3
M$128 \$I2977 \$I2976 \$I2978 GND nfet_03v3 L=0.28U W=0.44U AS=0.2684P
+ AD=0.2684P PS=2.1U PD=2.1U
* device instance $129 m90 *1 67.97,118.58 nfet_03v3
M$129 \$I2980 \$I2979 \$I2981 GND nfet_03v3 L=0.28U W=0.44U AS=0.2684P
+ AD=0.2684P PS=2.1U PD=2.1U
* device instance $130 r0 *1 79.69,107.1 nfet_03v3
M$130 \$I2983 \$I2982 \$I2984 GND nfet_03v3 L=0.28U W=0.44U AS=0.2684P
+ AD=0.2684P PS=2.1U PD=2.1U
* device instance $131 r0 *1 79.69,103.82 nfet_03v3
M$131 \$I2986 \$I2985 \$I2987 GND nfet_03v3 L=0.28U W=0.44U AS=0.2684P
+ AD=0.2684P PS=2.1U PD=2.1U
* device instance $132 r0 *1 79.69,105.46 nfet_03v3
M$132 \$I2989 \$I2988 \$I2990 GND nfet_03v3 L=0.28U W=0.44U AS=0.2684P
+ AD=0.2684P PS=2.1U PD=2.1U
* device instance $133 r0 *1 79.69,93.98 nfet_03v3
M$133 \$I2992 \$I2991 \$I2993 GND nfet_03v3 L=0.28U W=0.44U AS=0.2684P
+ AD=0.2684P PS=2.1U PD=2.1U
* device instance $134 r0 *1 79.69,95.62 nfet_03v3
M$134 \$I2995 \$I2994 \$I2996 GND nfet_03v3 L=0.28U W=0.44U AS=0.2684P
+ AD=0.2684P PS=2.1U PD=2.1U
* device instance $135 r0 *1 79.69,92.34 nfet_03v3
M$135 \$I2998 \$I2997 \$I2999 GND nfet_03v3 L=0.28U W=0.44U AS=0.2684P
+ AD=0.2684P PS=2.1U PD=2.1U
* device instance $136 r0 *1 79.69,90.7 nfet_03v3
M$136 \$I3001 \$I3000 \$I3002 GND nfet_03v3 L=0.28U W=0.44U AS=0.2684P
+ AD=0.2684P PS=2.1U PD=2.1U
* device instance $137 r0 *1 79.69,133.34 nfet_03v3
M$137 \$I3004 \$I3003 \$I3005 GND nfet_03v3 L=0.28U W=0.44U AS=0.2684P
+ AD=0.2684P PS=2.1U PD=2.1U
* device instance $138 r0 *1 79.69,108.74 nfet_03v3
M$138 \$I3007 \$I3006 \$I3008 GND nfet_03v3 L=0.28U W=0.44U AS=0.2684P
+ AD=0.2684P PS=2.1U PD=2.1U
* device instance $139 r0 *1 79.69,116.94 nfet_03v3
M$139 \$I3010 \$I3009 \$I3011 GND nfet_03v3 L=0.28U W=0.44U AS=0.2684P
+ AD=0.2684P PS=2.1U PD=2.1U
* device instance $140 r0 *1 79.69,118.58 nfet_03v3
M$140 \$I3013 \$I3012 \$I3014 GND nfet_03v3 L=0.28U W=0.44U AS=0.2684P
+ AD=0.2684P PS=2.1U PD=2.1U
* device instance $141 r0 *1 79.69,120.22 nfet_03v3
M$141 \$I3016 \$I3015 \$I3017 GND nfet_03v3 L=0.28U W=0.44U AS=0.2684P
+ AD=0.2684P PS=2.1U PD=2.1U
* device instance $142 r0 *1 79.69,131.7 nfet_03v3
M$142 \$I3019 \$I3018 \$I3020 GND nfet_03v3 L=0.28U W=0.44U AS=0.2684P
+ AD=0.2684P PS=2.1U PD=2.1U
* device instance $143 r0 *1 79.69,130.06 nfet_03v3
M$143 \$I3022 \$I3021 \$I3023 GND nfet_03v3 L=0.28U W=0.44U AS=0.2684P
+ AD=0.2684P PS=2.1U PD=2.1U
* device instance $144 r0 *1 79.69,121.86 nfet_03v3
M$144 \$I3025 \$I3024 \$I3026 GND nfet_03v3 L=0.28U W=0.44U AS=0.2684P
+ AD=0.2684P PS=2.1U PD=2.1U
* device instance $145 m90 *1 72.71,89.06 nfet_03v3
M$145 \$I3028 \$I3027 \$I3029 GND nfet_03v3 L=0.28U W=0.44U AS=0.2684P
+ AD=0.2684P PS=2.1U PD=2.1U
* device instance $146 r0 *1 60.73,89.06 nfet_03v3
M$146 \$I3031 \$I3030 \$I3032 GND nfet_03v3 L=0.28U W=0.44U AS=0.2684P
+ AD=0.2684P PS=2.1U PD=2.1U
* device instance $147 m90 *1 86.93,89.06 nfet_03v3
M$147 \$I3034 \$I3033 \$I3035 GND nfet_03v3 L=0.28U W=0.44U AS=0.2684P
+ AD=0.2684P PS=2.1U PD=2.1U
* device instance $148 r0 *1 84.43,89.06 nfet_03v3
M$148 \$I3037 \$I3036 \$I3038 GND nfet_03v3 L=0.28U W=0.44U AS=0.2684P
+ AD=0.2684P PS=2.1U PD=2.1U
* device instance $149 r0 *1 60.73,90.7 nfet_03v3
M$149 \$I3040 \$I3039 \$I3041 GND nfet_03v3 L=0.28U W=0.44U AS=0.2684P
+ AD=0.2684P PS=2.1U PD=2.1U
* device instance $150 r0 *1 84.43,95.62 nfet_03v3
M$150 \$I3043 \$I3042 \$I3044 GND nfet_03v3 L=0.28U W=0.44U AS=0.2684P
+ AD=0.2684P PS=2.1U PD=2.1U
* device instance $151 r0 *1 84.43,92.34 nfet_03v3
M$151 \$I3046 \$I3045 \$I3047 GND nfet_03v3 L=0.28U W=0.44U AS=0.2684P
+ AD=0.2684P PS=2.1U PD=2.1U
* device instance $152 r0 *1 84.43,102.18 nfet_03v3
M$152 \$I3049 \$I3048 \$I3050 GND nfet_03v3 L=0.28U W=0.44U AS=0.2684P
+ AD=0.2684P PS=2.1U PD=2.1U
* device instance $153 r0 *1 84.43,105.46 nfet_03v3
M$153 \$I3052 \$I3051 \$I3053 GND nfet_03v3 L=0.28U W=0.44U AS=0.2684P
+ AD=0.2684P PS=2.1U PD=2.1U
* device instance $154 r0 *1 84.43,112.02 nfet_03v3
M$154 \$I3055 \$I3054 \$I3056 GND nfet_03v3 L=0.28U W=0.44U AS=0.2684P
+ AD=0.2684P PS=2.1U PD=2.1U
* device instance $155 r0 *1 84.43,118.58 nfet_03v3
M$155 \$I3058 \$I3057 \$I3059 GND nfet_03v3 L=0.28U W=0.44U AS=0.2684P
+ AD=0.2684P PS=2.1U PD=2.1U
* device instance $156 r0 *1 84.43,128.42 nfet_03v3
M$156 \$I3061 \$I3060 \$I3062 GND nfet_03v3 L=0.28U W=0.44U AS=0.2684P
+ AD=0.2684P PS=2.1U PD=2.1U
* device instance $157 r0 *1 84.43,108.74 nfet_03v3
M$157 \$I3064 \$I3063 \$I3065 GND nfet_03v3 L=0.28U W=0.44U AS=0.2684P
+ AD=0.2684P PS=2.1U PD=2.1U
* device instance $158 r0 *1 84.43,115.3 nfet_03v3
M$158 \$I3067 \$I3066 \$I3068 GND nfet_03v3 L=0.28U W=0.44U AS=0.2684P
+ AD=0.2684P PS=2.1U PD=2.1U
* device instance $159 r0 *1 84.43,98.9 nfet_03v3
M$159 \$I3070 \$I3069 \$I3071 GND nfet_03v3 L=0.28U W=0.44U AS=0.2684P
+ AD=0.2684P PS=2.1U PD=2.1U
* device instance $160 r0 *1 84.43,131.7 nfet_03v3
M$160 \$I3073 \$I3072 \$I3074 GND nfet_03v3 L=0.28U W=0.44U AS=0.2684P
+ AD=0.2684P PS=2.1U PD=2.1U
* device instance $161 r0 *1 84.43,121.86 nfet_03v3
M$161 \$I3076 \$I3075 \$I3077 GND nfet_03v3 L=0.28U W=0.44U AS=0.2684P
+ AD=0.2684P PS=2.1U PD=2.1U
* device instance $162 r0 *1 84.43,125.14 nfet_03v3
M$162 \$I3079 \$I3078 \$I3080 GND nfet_03v3 L=0.28U W=0.44U AS=0.2684P
+ AD=0.2684P PS=2.1U PD=2.1U
* device instance $163 m90 *1 72.71,95.62 nfet_03v3
M$163 \$I3082 \$I3081 \$I3083 GND nfet_03v3 L=0.28U W=0.44U AS=0.2684P
+ AD=0.2684P PS=2.1U PD=2.1U
* device instance $164 m90 *1 72.71,98.9 nfet_03v3
M$164 \$I3085 \$I3084 \$I3086 GND nfet_03v3 L=0.28U W=0.44U AS=0.2684P
+ AD=0.2684P PS=2.1U PD=2.1U
* device instance $165 m90 *1 72.71,92.34 nfet_03v3
M$165 \$I3088 \$I3087 \$I3089 GND nfet_03v3 L=0.28U W=0.44U AS=0.2684P
+ AD=0.2684P PS=2.1U PD=2.1U
* device instance $166 m90 *1 72.71,112.02 nfet_03v3
M$166 \$I3091 \$I3090 \$I3092 GND nfet_03v3 L=0.28U W=0.44U AS=0.2684P
+ AD=0.2684P PS=2.1U PD=2.1U
* device instance $167 m90 *1 72.71,105.46 nfet_03v3
M$167 \$I3094 \$I3093 \$I3095 GND nfet_03v3 L=0.28U W=0.44U AS=0.2684P
+ AD=0.2684P PS=2.1U PD=2.1U
* device instance $168 m90 *1 72.71,108.74 nfet_03v3
M$168 \$I3097 \$I3096 \$I3098 GND nfet_03v3 L=0.28U W=0.44U AS=0.2684P
+ AD=0.2684P PS=2.1U PD=2.1U
* device instance $169 m90 *1 72.71,102.18 nfet_03v3
M$169 \$I3100 \$I3099 \$I3101 GND nfet_03v3 L=0.28U W=0.44U AS=0.2684P
+ AD=0.2684P PS=2.1U PD=2.1U
* device instance $170 m90 *1 72.71,118.58 nfet_03v3
M$170 \$I3103 \$I3102 \$I3104 GND nfet_03v3 L=0.28U W=0.44U AS=0.2684P
+ AD=0.2684P PS=2.1U PD=2.1U
* device instance $171 m90 *1 72.71,115.3 nfet_03v3
M$171 \$I3106 \$I3105 \$I3107 GND nfet_03v3 L=0.28U W=0.44U AS=0.2684P
+ AD=0.2684P PS=2.1U PD=2.1U
* device instance $172 m90 *1 72.71,125.14 nfet_03v3
M$172 \$I3109 \$I3108 \$I3110 GND nfet_03v3 L=0.28U W=0.44U AS=0.2684P
+ AD=0.2684P PS=2.1U PD=2.1U
* device instance $173 m90 *1 72.71,131.7 nfet_03v3
M$173 \$I3112 \$I3111 \$I3113 GND nfet_03v3 L=0.28U W=0.44U AS=0.2684P
+ AD=0.2684P PS=2.1U PD=2.1U
* device instance $174 m90 *1 72.71,121.86 nfet_03v3
M$174 \$I3115 \$I3114 \$I3116 GND nfet_03v3 L=0.28U W=0.44U AS=0.2684P
+ AD=0.2684P PS=2.1U PD=2.1U
* device instance $175 m90 *1 72.71,128.42 nfet_03v3
M$175 \$I3118 \$I3117 \$I3119 GND nfet_03v3 L=0.28U W=0.44U AS=0.2684P
+ AD=0.2684P PS=2.1U PD=2.1U
* device instance $176 m90 *1 86.93,90.7 nfet_03v3
M$176 \$I3121 \$I3120 \$I3122 GND nfet_03v3 L=0.28U W=0.44U AS=0.2684P
+ AD=0.2684P PS=2.1U PD=2.1U
* device instance $177 r0 *1 60.73,93.98 nfet_03v3
M$177 \$I3124 \$I3123 \$I3125 GND nfet_03v3 L=0.28U W=0.44U AS=0.2684P
+ AD=0.2684P PS=2.1U PD=2.1U
* device instance $178 r0 *1 60.73,92.34 nfet_03v3
M$178 \$I3127 \$I3126 \$I3128 GND nfet_03v3 L=0.28U W=0.44U AS=0.2684P
+ AD=0.2684P PS=2.1U PD=2.1U
* device instance $179 m90 *1 86.93,92.34 nfet_03v3
M$179 \$I3130 \$I3129 \$I3131 GND nfet_03v3 L=0.28U W=0.44U AS=0.2684P
+ AD=0.2684P PS=2.1U PD=2.1U
* device instance $180 m90 *1 86.93,93.98 nfet_03v3
M$180 \$I3133 \$I3132 \$I3134 GND nfet_03v3 L=0.28U W=0.44U AS=0.2684P
+ AD=0.2684P PS=2.1U PD=2.1U
* device instance $181 r0 *1 60.73,97.26 nfet_03v3
M$181 \$I3136 \$I3135 \$I3137 GND nfet_03v3 L=0.28U W=0.44U AS=0.2684P
+ AD=0.2684P PS=2.1U PD=2.1U
* device instance $182 r0 *1 60.73,95.62 nfet_03v3
M$182 \$I3139 \$I3138 \$I3140 GND nfet_03v3 L=0.28U W=0.44U AS=0.2684P
+ AD=0.2684P PS=2.1U PD=2.1U
* device instance $183 m90 *1 86.93,95.62 nfet_03v3
M$183 \$I3142 \$I3141 \$I3143 GND nfet_03v3 L=0.28U W=0.44U AS=0.2684P
+ AD=0.2684P PS=2.1U PD=2.1U
* device instance $184 m90 *1 86.93,97.26 nfet_03v3
M$184 \$I3145 \$I3144 \$I3146 GND nfet_03v3 L=0.28U W=0.44U AS=0.2684P
+ AD=0.2684P PS=2.1U PD=2.1U
* device instance $185 r0 *1 60.73,98.9 nfet_03v3
M$185 \$I3148 \$I3147 \$I3149 GND nfet_03v3 L=0.28U W=0.44U AS=0.2684P
+ AD=0.2684P PS=2.1U PD=2.1U
* device instance $186 m90 *1 86.93,98.9 nfet_03v3
M$186 \$I3151 \$I3150 \$I3152 GND nfet_03v3 L=0.28U W=0.44U AS=0.2684P
+ AD=0.2684P PS=2.1U PD=2.1U
* device instance $187 m90 *1 86.93,100.54 nfet_03v3
M$187 \$I3154 \$I3153 \$I3155 GND nfet_03v3 L=0.28U W=0.44U AS=0.2684P
+ AD=0.2684P PS=2.1U PD=2.1U
* device instance $188 r0 *1 60.73,100.54 nfet_03v3
M$188 \$I3157 \$I3156 \$I3158 GND nfet_03v3 L=0.28U W=0.44U AS=0.2684P
+ AD=0.2684P PS=2.1U PD=2.1U
* device instance $189 r0 *1 60.73,102.18 nfet_03v3
M$189 \$I3160 \$I3159 \$I3161 GND nfet_03v3 L=0.28U W=0.44U AS=0.2684P
+ AD=0.2684P PS=2.1U PD=2.1U
* device instance $190 m90 *1 86.93,103.82 nfet_03v3
M$190 \$I3163 \$I3162 \$I3164 GND nfet_03v3 L=0.28U W=0.44U AS=0.2684P
+ AD=0.2684P PS=2.1U PD=2.1U
* device instance $191 m90 *1 86.93,102.18 nfet_03v3
M$191 \$I3166 \$I3165 \$I3167 GND nfet_03v3 L=0.28U W=0.44U AS=0.2684P
+ AD=0.2684P PS=2.1U PD=2.1U
* device instance $192 r0 *1 60.73,103.82 nfet_03v3
M$192 \$I3169 \$I3168 \$I3170 GND nfet_03v3 L=0.28U W=0.44U AS=0.2684P
+ AD=0.2684P PS=2.1U PD=2.1U
* device instance $193 r0 *1 60.73,105.46 nfet_03v3
M$193 \$I3172 \$I3171 \$I3173 GND nfet_03v3 L=0.28U W=0.44U AS=0.2684P
+ AD=0.2684P PS=2.1U PD=2.1U
* device instance $194 m90 *1 86.93,107.1 nfet_03v3
M$194 \$I3175 \$I3174 \$I3176 GND nfet_03v3 L=0.28U W=0.44U AS=0.2684P
+ AD=0.2684P PS=2.1U PD=2.1U
* device instance $195 m90 *1 86.93,105.46 nfet_03v3
M$195 \$I3178 \$I3177 \$I3179 GND nfet_03v3 L=0.28U W=0.44U AS=0.2684P
+ AD=0.2684P PS=2.1U PD=2.1U
* device instance $196 r0 *1 60.73,107.1 nfet_03v3
M$196 \$I3181 \$I3180 \$I3182 GND nfet_03v3 L=0.28U W=0.44U AS=0.2684P
+ AD=0.2684P PS=2.1U PD=2.1U
* device instance $197 r0 *1 60.73,108.74 nfet_03v3
M$197 \$I3184 \$I3183 \$I3185 GND nfet_03v3 L=0.28U W=0.44U AS=0.2684P
+ AD=0.2684P PS=2.1U PD=2.1U
* device instance $198 m90 *1 86.93,108.74 nfet_03v3
M$198 \$I3187 \$I3186 \$I3188 GND nfet_03v3 L=0.28U W=0.44U AS=0.2684P
+ AD=0.2684P PS=2.1U PD=2.1U
* device instance $199 r0 *1 60.73,110.38 nfet_03v3
M$199 \$I3190 \$I3189 \$I3191 GND nfet_03v3 L=0.28U W=0.44U AS=0.2684P
+ AD=0.2684P PS=2.1U PD=2.1U
* device instance $200 r0 *1 60.73,112.02 nfet_03v3
M$200 \$I3193 \$I3192 \$I3194 GND nfet_03v3 L=0.28U W=0.44U AS=0.2684P
+ AD=0.2684P PS=2.1U PD=2.1U
* device instance $201 m90 *1 86.93,112.02 nfet_03v3
M$201 \$I3196 \$I3195 \$I3197 GND nfet_03v3 L=0.28U W=0.44U AS=0.2684P
+ AD=0.2684P PS=2.1U PD=2.1U
* device instance $202 m90 *1 86.93,110.38 nfet_03v3
M$202 \$I3199 \$I3198 \$I3200 GND nfet_03v3 L=0.28U W=0.44U AS=0.2684P
+ AD=0.2684P PS=2.1U PD=2.1U
* device instance $203 r0 *1 60.73,113.66 nfet_03v3
M$203 \$I3202 \$I3201 \$I3203 GND nfet_03v3 L=0.28U W=0.44U AS=0.2684P
+ AD=0.2684P PS=2.1U PD=2.1U
* device instance $204 m90 *1 86.93,113.66 nfet_03v3
M$204 \$I3205 \$I3204 \$I3206 GND nfet_03v3 L=0.28U W=0.44U AS=0.2684P
+ AD=0.2684P PS=2.1U PD=2.1U
* device instance $205 r0 *1 60.73,116.94 nfet_03v3
M$205 \$I3208 \$I3207 \$I3209 GND nfet_03v3 L=0.28U W=0.44U AS=0.2684P
+ AD=0.2684P PS=2.1U PD=2.1U
* device instance $206 r0 *1 60.73,115.3 nfet_03v3
M$206 \$I3211 \$I3210 \$I3212 GND nfet_03v3 L=0.28U W=0.44U AS=0.2684P
+ AD=0.2684P PS=2.1U PD=2.1U
* device instance $207 m90 *1 86.93,115.3 nfet_03v3
M$207 \$I3214 \$I3213 \$I3215 GND nfet_03v3 L=0.28U W=0.44U AS=0.2684P
+ AD=0.2684P PS=2.1U PD=2.1U
* device instance $208 m90 *1 86.93,116.94 nfet_03v3
M$208 \$I3217 \$I3216 \$I3218 GND nfet_03v3 L=0.28U W=0.44U AS=0.2684P
+ AD=0.2684P PS=2.1U PD=2.1U
* device instance $209 r0 *1 60.73,118.58 nfet_03v3
M$209 \$I3220 \$I3219 \$I3221 GND nfet_03v3 L=0.28U W=0.44U AS=0.2684P
+ AD=0.2684P PS=2.1U PD=2.1U
* device instance $210 r0 *1 60.73,120.22 nfet_03v3
M$210 \$I3223 \$I3222 \$I3224 GND nfet_03v3 L=0.28U W=0.44U AS=0.2684P
+ AD=0.2684P PS=2.1U PD=2.1U
* device instance $211 m90 *1 86.93,118.58 nfet_03v3
M$211 \$I3226 \$I3225 \$I3227 GND nfet_03v3 L=0.28U W=0.44U AS=0.2684P
+ AD=0.2684P PS=2.1U PD=2.1U
* device instance $212 m90 *1 86.93,120.22 nfet_03v3
M$212 \$I3229 \$I3228 \$I3230 GND nfet_03v3 L=0.28U W=0.44U AS=0.2684P
+ AD=0.2684P PS=2.1U PD=2.1U
* device instance $213 r0 *1 60.73,123.5 nfet_03v3
M$213 \$I3232 \$I3231 \$I3233 GND nfet_03v3 L=0.28U W=0.44U AS=0.2684P
+ AD=0.2684P PS=2.1U PD=2.1U
* device instance $214 r0 *1 60.73,121.86 nfet_03v3
M$214 \$I3235 \$I3234 \$I3236 GND nfet_03v3 L=0.28U W=0.44U AS=0.2684P
+ AD=0.2684P PS=2.1U PD=2.1U
* device instance $215 m90 *1 86.93,121.86 nfet_03v3
M$215 \$I3238 \$I3237 \$I3239 GND nfet_03v3 L=0.28U W=0.44U AS=0.2684P
+ AD=0.2684P PS=2.1U PD=2.1U
* device instance $216 m90 *1 86.93,123.5 nfet_03v3
M$216 \$I3241 \$I3240 \$I3242 GND nfet_03v3 L=0.28U W=0.44U AS=0.2684P
+ AD=0.2684P PS=2.1U PD=2.1U
* device instance $217 r0 *1 60.73,125.14 nfet_03v3
M$217 \$I3244 \$I3243 \$I3245 GND nfet_03v3 L=0.28U W=0.44U AS=0.2684P
+ AD=0.2684P PS=2.1U PD=2.1U
* device instance $218 m90 *1 86.93,125.14 nfet_03v3
M$218 \$I3247 \$I3246 \$I3248 GND nfet_03v3 L=0.28U W=0.44U AS=0.2684P
+ AD=0.2684P PS=2.1U PD=2.1U
* device instance $219 r0 *1 60.73,128.42 nfet_03v3
M$219 \$I3250 \$I3249 \$I3251 GND nfet_03v3 L=0.28U W=0.44U AS=0.2684P
+ AD=0.2684P PS=2.1U PD=2.1U
* device instance $220 r0 *1 60.73,126.78 nfet_03v3
M$220 \$I3253 \$I3252 \$I3254 GND nfet_03v3 L=0.28U W=0.44U AS=0.2684P
+ AD=0.2684P PS=2.1U PD=2.1U
* device instance $221 m90 *1 86.93,126.78 nfet_03v3
M$221 \$I3256 \$I3255 \$I3257 GND nfet_03v3 L=0.28U W=0.44U AS=0.2684P
+ AD=0.2684P PS=2.1U PD=2.1U
* device instance $222 m90 *1 86.93,128.42 nfet_03v3
M$222 \$I3259 \$I3258 \$I3260 GND nfet_03v3 L=0.28U W=0.44U AS=0.2684P
+ AD=0.2684P PS=2.1U PD=2.1U
* device instance $223 r0 *1 60.73,130.06 nfet_03v3
M$223 \$I3262 \$I3261 \$I3263 GND nfet_03v3 L=0.28U W=0.44U AS=0.2684P
+ AD=0.2684P PS=2.1U PD=2.1U
* device instance $224 m90 *1 86.93,130.06 nfet_03v3
M$224 \$I3265 \$I3264 \$I3266 GND nfet_03v3 L=0.28U W=0.44U AS=0.2684P
+ AD=0.2684P PS=2.1U PD=2.1U
* device instance $225 m90 *1 86.93,131.7 nfet_03v3
M$225 \$I3268 \$I3267 \$I3269 GND nfet_03v3 L=0.28U W=0.44U AS=0.2684P
+ AD=0.2684P PS=2.1U PD=2.1U
* device instance $226 r0 *1 60.73,131.7 nfet_03v3
M$226 \$I3271 \$I3270 \$I3272 GND nfet_03v3 L=0.28U W=0.44U AS=0.2684P
+ AD=0.2684P PS=2.1U PD=2.1U
* device instance $227 r0 *1 60.73,133.34 nfet_03v3
M$227 \$I3274 \$I3273 \$I3275 GND nfet_03v3 L=0.28U W=0.44U AS=0.2684P
+ AD=0.2684P PS=2.1U PD=2.1U
* device instance $228 m90 *1 86.93,133.34 nfet_03v3
M$228 \$I3277 \$I3276 \$I3278 GND nfet_03v3 L=0.28U W=0.44U AS=0.2684P
+ AD=0.2684P PS=2.1U PD=2.1U
* device instance $229 r270 *1 60.795,145.56 ppolyf_u_1k
R$229 VDD \$294 GND 20000 ppolyf_u_1k L=20U W=1U
* device instance $230 r270 *1 70.275,145.56 ppolyf_u_1k
R$230 VDD \$16 GND 20000 ppolyf_u_1k L=20U W=1U
* device instance $231 r270 *1 84.495,145.56 ppolyf_u_1k
R$231 VDD \$91 GND 20000 ppolyf_u_1k L=20U W=1U
* device instance $232 r270 *1 72.645,145.56 ppolyf_u_1k
R$232 VDD \$96 GND 20000 ppolyf_u_1k L=20U W=1U
* device instance $233 r270 *1 79.755,145.56 ppolyf_u_1k
R$233 VDD \$79 GND 20000 ppolyf_u_1k L=20U W=1U
* device instance $234 r270 *1 77.385,145.56 ppolyf_u_1k
R$234 VDD \$37 GND 20000 ppolyf_u_1k L=20U W=1U
* device instance $235 r270 *1 82.125,145.56 ppolyf_u_1k
R$235 VDD \$17 GND 20000 ppolyf_u_1k L=20U W=1U
* device instance $236 r270 *1 75.015,145.56 ppolyf_u_1k
R$236 VDD \$61 GND 20000 ppolyf_u_1k L=20U W=1U
* device instance $237 r270 *1 86.865,145.56 ppolyf_u_1k
R$237 VDD \$305 GND 20000 ppolyf_u_1k L=20U W=1U
* device instance $238 r270 *1 63.165,145.56 ppolyf_u_1k
R$238 VDD \$59 GND 20000 ppolyf_u_1k L=20U W=1U
* device instance $239 r270 *1 65.535,145.56 ppolyf_u_1k
R$239 VDD \$36 GND 20000 ppolyf_u_1k L=20U W=1U
* device instance $240 r270 *1 67.905,145.56 ppolyf_u_1k
R$240 VDD \$72 GND 20000 ppolyf_u_1k L=20U W=1U
* device instance $241 m135 *1 57.11,65.58 pfet_03v3
M$241 B0 \$1 VDD VDD pfet_03v3 L=0.28U W=1.32U AS=0.5148P AD=0.5148P PS=4.1U
+ PD=4.1U
* device instance $244 r270 *1 59.07,65.58 pfet_03v3
M$244 B1 \$2 VDD VDD pfet_03v3 L=0.28U W=1.32U AS=0.5148P AD=0.5148P PS=4.1U
+ PD=4.1U
* device instance $247 m45 *1 59.07,73.4 pfet_03v3
M$247 B3 \$35 VDD VDD pfet_03v3 L=0.28U W=1.32U AS=0.5148P AD=0.5148P PS=4.1U
+ PD=4.1U
* device instance $250 r90 *1 61.15,73.4 pfet_03v3
M$250 B2 \$26 VDD VDD pfet_03v3 L=0.28U W=1.32U AS=0.5148P AD=0.5148P PS=4.1U
+ PD=4.1U
* device instance $253 r90 *1 86.39,69.18 pfet_03v3
M$253 \$7 THERMOMETER_31 VDD VDD pfet_03v3 L=0.28U W=1.32U AS=0.5148P
+ AD=0.5148P PS=4.1U PD=4.1U
* device instance $256 r90 *1 57.11,73.4 pfet_03v3
M$256 B4 \$43 VDD VDD pfet_03v3 L=0.28U W=1.32U AS=0.5148P AD=0.5148P PS=4.1U
+ PD=4.1U
* device instance $259 r0 *1 70.21,105.46 nfet_03v3
M$259 GND IN17 \$16 GND nfet_03v3 L=0.28U W=0.44U AS=0.2684P AD=0.2684P PS=2.1U
+ PD=2.1U
* device instance $260 r0 *1 70.21,112.02 nfet_03v3
M$260 GND IN13 \$16 GND nfet_03v3 L=0.28U W=0.44U AS=0.2684P AD=0.2684P PS=2.1U
+ PD=2.1U
* device instance $261 r0 *1 70.21,92.34 nfet_03v3
M$261 GND IN25 \$16 GND nfet_03v3 L=0.28U W=0.44U AS=0.2684P AD=0.2684P PS=2.1U
+ PD=2.1U
* device instance $262 r0 *1 70.21,116.94 nfet_03v3
M$262 GND IN10 \$16 GND nfet_03v3 L=0.28U W=0.44U AS=0.2684P AD=0.2684P PS=2.1U
+ PD=2.1U
* device instance $263 r0 *1 70.21,85.78 nfet_03v3
M$263 GND IN29 \$16 GND nfet_03v3 L=0.28U W=0.44U AS=0.2684P AD=0.2684P PS=2.1U
+ PD=2.1U
* device instance $264 r0 *1 70.21,98.9 nfet_03v3
M$264 GND IN21 \$16 GND nfet_03v3 L=0.28U W=0.44U AS=0.2684P AD=0.2684P PS=2.1U
+ PD=2.1U
* device instance $265 r0 *1 70.21,97.26 nfet_03v3
M$265 GND IN22 \$16 GND nfet_03v3 L=0.28U W=0.44U AS=0.2684P AD=0.2684P PS=2.1U
+ PD=2.1U
* device instance $266 r0 *1 70.21,118.58 nfet_03v3
M$266 GND IN9 \$16 GND nfet_03v3 L=0.28U W=0.44U AS=0.2684P AD=0.2684P PS=2.1U
+ PD=2.1U
* device instance $267 r0 *1 70.21,110.38 nfet_03v3
M$267 GND IN14 \$16 GND nfet_03v3 L=0.28U W=0.44U AS=0.2684P AD=0.2684P PS=2.1U
+ PD=2.1U
* device instance $268 r0 *1 70.21,90.7 nfet_03v3
M$268 GND IN26 \$16 GND nfet_03v3 L=0.28U W=0.44U AS=0.2684P AD=0.2684P PS=2.1U
+ PD=2.1U
* device instance $269 r0 *1 70.21,103.82 nfet_03v3
M$269 GND IN18 \$16 GND nfet_03v3 L=0.28U W=0.44U AS=0.2684P AD=0.2684P PS=2.1U
+ PD=2.1U
* device instance $270 r0 *1 70.21,84.14 nfet_03v3
M$270 GND IN30 \$16 GND nfet_03v3 L=0.28U W=0.44U AS=0.2684P AD=0.2684P PS=2.1U
+ PD=2.1U
* device instance $271 r0 *1 70.21,125.14 nfet_03v3
M$271 GND IN5 \$16 GND nfet_03v3 L=0.28U W=0.44U AS=0.2684P AD=0.2684P PS=2.1U
+ PD=2.1U
* device instance $272 r0 *1 70.21,131.7 nfet_03v3
M$272 GND IN1 \$16 GND nfet_03v3 L=0.28U W=0.44U AS=0.2684P AD=0.2684P PS=2.1U
+ PD=2.1U
* device instance $273 r0 *1 70.21,130.06 nfet_03v3
M$273 GND IN2 \$16 GND nfet_03v3 L=0.28U W=0.44U AS=0.2684P AD=0.2684P PS=2.1U
+ PD=2.1U
* device instance $274 r0 *1 70.21,123.5 nfet_03v3
M$274 GND IN6 \$16 GND nfet_03v3 L=0.28U W=0.44U AS=0.2684P AD=0.2684P PS=2.1U
+ PD=2.1U
* device instance $275 m90 *1 82.19,116.94 nfet_03v3
M$275 GND IN42 \$17 GND nfet_03v3 L=0.28U W=0.44U AS=0.2684P AD=0.2684P PS=2.1U
+ PD=2.1U
* device instance $276 m90 *1 82.19,97.26 nfet_03v3
M$276 GND IN54 \$17 GND nfet_03v3 L=0.28U W=0.44U AS=0.2684P AD=0.2684P PS=2.1U
+ PD=2.1U
* device instance $277 m90 *1 82.19,90.7 nfet_03v3
M$277 GND IN58 \$17 GND nfet_03v3 L=0.28U W=0.44U AS=0.2684P AD=0.2684P PS=2.1U
+ PD=2.1U
* device instance $278 m90 *1 82.19,85.78 nfet_03v3
M$278 GND IN61 \$17 GND nfet_03v3 L=0.28U W=0.44U AS=0.2684P AD=0.2684P PS=2.1U
+ PD=2.1U
* device instance $279 m90 *1 82.19,98.9 nfet_03v3
M$279 GND IN53 \$17 GND nfet_03v3 L=0.28U W=0.44U AS=0.2684P AD=0.2684P PS=2.1U
+ PD=2.1U
* device instance $280 m90 *1 82.19,92.34 nfet_03v3
M$280 GND IN57 \$17 GND nfet_03v3 L=0.28U W=0.44U AS=0.2684P AD=0.2684P PS=2.1U
+ PD=2.1U
* device instance $281 m90 *1 82.19,131.7 nfet_03v3
M$281 GND IN33 \$17 GND nfet_03v3 L=0.28U W=0.44U AS=0.2684P AD=0.2684P PS=2.1U
+ PD=2.1U
* device instance $282 m90 *1 82.19,130.06 nfet_03v3
M$282 GND IN34 \$17 GND nfet_03v3 L=0.28U W=0.44U AS=0.2684P AD=0.2684P PS=2.1U
+ PD=2.1U
* device instance $283 m90 *1 82.19,123.5 nfet_03v3
M$283 GND IN38 \$17 GND nfet_03v3 L=0.28U W=0.44U AS=0.2684P AD=0.2684P PS=2.1U
+ PD=2.1U
* device instance $284 m90 *1 82.19,112.02 nfet_03v3
M$284 GND IN45 \$17 GND nfet_03v3 L=0.28U W=0.44U AS=0.2684P AD=0.2684P PS=2.1U
+ PD=2.1U
* device instance $285 m90 *1 82.19,118.58 nfet_03v3
M$285 GND IN41 \$17 GND nfet_03v3 L=0.28U W=0.44U AS=0.2684P AD=0.2684P PS=2.1U
+ PD=2.1U
* device instance $286 m90 *1 82.19,110.38 nfet_03v3
M$286 GND IN46 \$17 GND nfet_03v3 L=0.28U W=0.44U AS=0.2684P AD=0.2684P PS=2.1U
+ PD=2.1U
* device instance $287 m90 *1 82.19,125.14 nfet_03v3
M$287 GND IN37 \$17 GND nfet_03v3 L=0.28U W=0.44U AS=0.2684P AD=0.2684P PS=2.1U
+ PD=2.1U
* device instance $288 m90 *1 82.19,103.82 nfet_03v3
M$288 GND IN50 \$17 GND nfet_03v3 L=0.28U W=0.44U AS=0.2684P AD=0.2684P PS=2.1U
+ PD=2.1U
* device instance $289 m90 *1 82.19,84.14 nfet_03v3
M$289 GND IN62 \$17 GND nfet_03v3 L=0.28U W=0.44U AS=0.2684P AD=0.2684P PS=2.1U
+ PD=2.1U
* device instance $290 m90 *1 82.19,105.46 nfet_03v3
M$290 GND IN49 \$17 GND nfet_03v3 L=0.28U W=0.44U AS=0.2684P AD=0.2684P PS=2.1U
+ PD=2.1U
* device instance $291 r0 *1 65.47,116.94 nfet_03v3
M$291 GND IN10 \$36 GND nfet_03v3 L=0.28U W=0.44U AS=0.2684P AD=0.2684P PS=2.1U
+ PD=2.1U
* device instance $292 r0 *1 65.47,112.02 nfet_03v3
M$292 GND IN13 \$36 GND nfet_03v3 L=0.28U W=0.44U AS=0.2684P AD=0.2684P PS=2.1U
+ PD=2.1U
* device instance $293 r0 *1 65.47,118.58 nfet_03v3
M$293 GND IN9 \$36 GND nfet_03v3 L=0.28U W=0.44U AS=0.2684P AD=0.2684P PS=2.1U
+ PD=2.1U
* device instance $294 r0 *1 65.47,92.34 nfet_03v3
M$294 GND IN25 \$36 GND nfet_03v3 L=0.28U W=0.44U AS=0.2684P AD=0.2684P PS=2.1U
+ PD=2.1U
* device instance $295 r0 *1 65.47,84.14 nfet_03v3
M$295 GND IN30 \$36 GND nfet_03v3 L=0.28U W=0.44U AS=0.2684P AD=0.2684P PS=2.1U
+ PD=2.1U
* device instance $296 r0 *1 65.47,113.66 nfet_03v3
M$296 GND IN12 \$36 GND nfet_03v3 L=0.28U W=0.44U AS=0.2684P AD=0.2684P PS=2.1U
+ PD=2.1U
* device instance $297 r0 *1 65.47,115.3 nfet_03v3
M$297 GND IN11 \$36 GND nfet_03v3 L=0.28U W=0.44U AS=0.2684P AD=0.2684P PS=2.1U
+ PD=2.1U
* device instance $298 r0 *1 65.47,95.62 nfet_03v3
M$298 GND IN23 \$36 GND nfet_03v3 L=0.28U W=0.44U AS=0.2684P AD=0.2684P PS=2.1U
+ PD=2.1U
* device instance $299 r0 *1 65.47,93.98 nfet_03v3
M$299 GND IN24 \$36 GND nfet_03v3 L=0.28U W=0.44U AS=0.2684P AD=0.2684P PS=2.1U
+ PD=2.1U
* device instance $300 r0 *1 65.47,89.06 nfet_03v3
M$300 GND IN27 \$36 GND nfet_03v3 L=0.28U W=0.44U AS=0.2684P AD=0.2684P PS=2.1U
+ PD=2.1U
* device instance $301 r0 *1 65.47,110.38 nfet_03v3
M$301 GND IN14 \$36 GND nfet_03v3 L=0.28U W=0.44U AS=0.2684P AD=0.2684P PS=2.1U
+ PD=2.1U
* device instance $302 r0 *1 65.47,90.7 nfet_03v3
M$302 GND IN26 \$36 GND nfet_03v3 L=0.28U W=0.44U AS=0.2684P AD=0.2684P PS=2.1U
+ PD=2.1U
* device instance $303 r0 *1 65.47,85.78 nfet_03v3
M$303 GND IN29 \$36 GND nfet_03v3 L=0.28U W=0.44U AS=0.2684P AD=0.2684P PS=2.1U
+ PD=2.1U
* device instance $304 r0 *1 65.47,121.86 nfet_03v3
M$304 GND IN7 \$36 GND nfet_03v3 L=0.28U W=0.44U AS=0.2684P AD=0.2684P PS=2.1U
+ PD=2.1U
* device instance $305 r0 *1 65.47,87.42 nfet_03v3
M$305 GND IN28 \$36 GND nfet_03v3 L=0.28U W=0.44U AS=0.2684P AD=0.2684P PS=2.1U
+ PD=2.1U
* device instance $306 r0 *1 65.47,120.22 nfet_03v3
M$306 GND IN8 \$36 GND nfet_03v3 L=0.28U W=0.44U AS=0.2684P AD=0.2684P PS=2.1U
+ PD=2.1U
* device instance $307 m90 *1 77.45,95.62 nfet_03v3
M$307 GND IN55 \$37 GND nfet_03v3 L=0.28U W=0.44U AS=0.2684P AD=0.2684P PS=2.1U
+ PD=2.1U
* device instance $308 m90 *1 77.45,113.66 nfet_03v3
M$308 GND IN44 \$37 GND nfet_03v3 L=0.28U W=0.44U AS=0.2684P AD=0.2684P PS=2.1U
+ PD=2.1U
* device instance $309 m90 *1 77.45,115.3 nfet_03v3
M$309 GND IN43 \$37 GND nfet_03v3 L=0.28U W=0.44U AS=0.2684P AD=0.2684P PS=2.1U
+ PD=2.1U
* device instance $310 m90 *1 77.45,116.94 nfet_03v3
M$310 GND IN42 \$37 GND nfet_03v3 L=0.28U W=0.44U AS=0.2684P AD=0.2684P PS=2.1U
+ PD=2.1U
* device instance $311 m90 *1 77.45,110.38 nfet_03v3
M$311 GND IN46 \$37 GND nfet_03v3 L=0.28U W=0.44U AS=0.2684P AD=0.2684P PS=2.1U
+ PD=2.1U
* device instance $312 m90 *1 77.45,84.14 nfet_03v3
M$312 GND IN62 \$37 GND nfet_03v3 L=0.28U W=0.44U AS=0.2684P AD=0.2684P PS=2.1U
+ PD=2.1U
* device instance $313 m90 *1 77.45,120.22 nfet_03v3
M$313 GND IN40 \$37 GND nfet_03v3 L=0.28U W=0.44U AS=0.2684P AD=0.2684P PS=2.1U
+ PD=2.1U
* device instance $314 m90 *1 77.45,87.42 nfet_03v3
M$314 GND IN60 \$37 GND nfet_03v3 L=0.28U W=0.44U AS=0.2684P AD=0.2684P PS=2.1U
+ PD=2.1U
* device instance $315 m90 *1 77.45,92.34 nfet_03v3
M$315 GND IN57 \$37 GND nfet_03v3 L=0.28U W=0.44U AS=0.2684P AD=0.2684P PS=2.1U
+ PD=2.1U
* device instance $316 m90 *1 77.45,93.98 nfet_03v3
M$316 GND IN56 \$37 GND nfet_03v3 L=0.28U W=0.44U AS=0.2684P AD=0.2684P PS=2.1U
+ PD=2.1U
* device instance $317 m90 *1 77.45,118.58 nfet_03v3
M$317 GND IN41 \$37 GND nfet_03v3 L=0.28U W=0.44U AS=0.2684P AD=0.2684P PS=2.1U
+ PD=2.1U
* device instance $318 m90 *1 77.45,121.86 nfet_03v3
M$318 GND IN39 \$37 GND nfet_03v3 L=0.28U W=0.44U AS=0.2684P AD=0.2684P PS=2.1U
+ PD=2.1U
* device instance $319 m90 *1 77.45,112.02 nfet_03v3
M$319 GND IN45 \$37 GND nfet_03v3 L=0.28U W=0.44U AS=0.2684P AD=0.2684P PS=2.1U
+ PD=2.1U
* device instance $320 m90 *1 77.45,89.06 nfet_03v3
M$320 GND IN59 \$37 GND nfet_03v3 L=0.28U W=0.44U AS=0.2684P AD=0.2684P PS=2.1U
+ PD=2.1U
* device instance $321 m90 *1 77.45,90.7 nfet_03v3
M$321 GND IN58 \$37 GND nfet_03v3 L=0.28U W=0.44U AS=0.2684P AD=0.2684P PS=2.1U
+ PD=2.1U
* device instance $322 m90 *1 77.45,85.78 nfet_03v3
M$322 GND IN61 \$37 GND nfet_03v3 L=0.28U W=0.44U AS=0.2684P AD=0.2684P PS=2.1U
+ PD=2.1U
* device instance $323 m90 *1 72.71,84.14 nfet_03v3
M$323 GND IN30 \$96 GND nfet_03v3 L=0.28U W=0.44U AS=0.2684P AD=0.2684P PS=2.1U
+ PD=2.1U
* device instance $324 m90 *1 67.97,84.14 nfet_03v3
M$324 GND IN30 \$72 GND nfet_03v3 L=0.28U W=0.44U AS=0.2684P AD=0.2684P PS=2.1U
+ PD=2.1U
* device instance $325 m90 *1 63.23,84.14 nfet_03v3
M$325 GND IN30 \$59 GND nfet_03v3 L=0.28U W=0.44U AS=0.2684P AD=0.2684P PS=2.1U
+ PD=2.1U
* device instance $326 r0 *1 74.95,84.14 nfet_03v3
M$326 GND IN62 \$61 GND nfet_03v3 L=0.28U W=0.44U AS=0.2684P AD=0.2684P PS=2.1U
+ PD=2.1U
* device instance $327 r0 *1 84.43,84.14 nfet_03v3
M$327 GND IN62 \$91 GND nfet_03v3 L=0.28U W=0.44U AS=0.2684P AD=0.2684P PS=2.1U
+ PD=2.1U
* device instance $328 r0 *1 79.69,84.14 nfet_03v3
M$328 GND IN62 \$79 GND nfet_03v3 L=0.28U W=0.44U AS=0.2684P AD=0.2684P PS=2.1U
+ PD=2.1U
* device instance $329 m90 *1 63.23,108.74 nfet_03v3
M$329 GND IN15 \$59 GND nfet_03v3 L=0.28U W=0.44U AS=0.2684P AD=0.2684P PS=2.1U
+ PD=2.1U
* device instance $330 m90 *1 63.23,98.9 nfet_03v3
M$330 GND IN21 \$59 GND nfet_03v3 L=0.28U W=0.44U AS=0.2684P AD=0.2684P PS=2.1U
+ PD=2.1U
* device instance $331 m90 *1 63.23,102.18 nfet_03v3
M$331 GND IN19 \$59 GND nfet_03v3 L=0.28U W=0.44U AS=0.2684P AD=0.2684P PS=2.1U
+ PD=2.1U
* device instance $332 m90 *1 63.23,87.42 nfet_03v3
M$332 GND IN28 \$59 GND nfet_03v3 L=0.28U W=0.44U AS=0.2684P AD=0.2684P PS=2.1U
+ PD=2.1U
* device instance $333 m90 *1 63.23,85.78 nfet_03v3
M$333 GND IN29 \$59 GND nfet_03v3 L=0.28U W=0.44U AS=0.2684P AD=0.2684P PS=2.1U
+ PD=2.1U
* device instance $334 m90 *1 63.23,97.26 nfet_03v3
M$334 GND IN22 \$59 GND nfet_03v3 L=0.28U W=0.44U AS=0.2684P AD=0.2684P PS=2.1U
+ PD=2.1U
* device instance $335 m90 *1 63.23,93.98 nfet_03v3
M$335 GND IN24 \$59 GND nfet_03v3 L=0.28U W=0.44U AS=0.2684P AD=0.2684P PS=2.1U
+ PD=2.1U
* device instance $336 m90 *1 63.23,92.34 nfet_03v3
M$336 GND IN25 \$59 GND nfet_03v3 L=0.28U W=0.44U AS=0.2684P AD=0.2684P PS=2.1U
+ PD=2.1U
* device instance $337 m90 *1 63.23,89.06 nfet_03v3
M$337 GND IN27 \$59 GND nfet_03v3 L=0.28U W=0.44U AS=0.2684P AD=0.2684P PS=2.1U
+ PD=2.1U
* device instance $338 m90 *1 63.23,90.7 nfet_03v3
M$338 GND IN26 \$59 GND nfet_03v3 L=0.28U W=0.44U AS=0.2684P AD=0.2684P PS=2.1U
+ PD=2.1U
* device instance $339 m90 *1 63.23,95.62 nfet_03v3
M$339 GND IN23 \$59 GND nfet_03v3 L=0.28U W=0.44U AS=0.2684P AD=0.2684P PS=2.1U
+ PD=2.1U
* device instance $340 m90 *1 63.23,100.54 nfet_03v3
M$340 GND IN20 \$59 GND nfet_03v3 L=0.28U W=0.44U AS=0.2684P AD=0.2684P PS=2.1U
+ PD=2.1U
* device instance $341 m90 *1 63.23,103.82 nfet_03v3
M$341 GND IN18 \$59 GND nfet_03v3 L=0.28U W=0.44U AS=0.2684P AD=0.2684P PS=2.1U
+ PD=2.1U
* device instance $342 m90 *1 63.23,105.46 nfet_03v3
M$342 GND IN17 \$59 GND nfet_03v3 L=0.28U W=0.44U AS=0.2684P AD=0.2684P PS=2.1U
+ PD=2.1U
* device instance $343 m90 *1 63.23,107.1 nfet_03v3
M$343 GND IN16 \$59 GND nfet_03v3 L=0.28U W=0.44U AS=0.2684P AD=0.2684P PS=2.1U
+ PD=2.1U
* device instance $344 r0 *1 74.95,100.54 nfet_03v3
M$344 GND IN52 \$61 GND nfet_03v3 L=0.28U W=0.44U AS=0.2684P AD=0.2684P PS=2.1U
+ PD=2.1U
* device instance $345 r0 *1 74.95,105.46 nfet_03v3
M$345 GND IN49 \$61 GND nfet_03v3 L=0.28U W=0.44U AS=0.2684P AD=0.2684P PS=2.1U
+ PD=2.1U
* device instance $346 r0 *1 74.95,107.1 nfet_03v3
M$346 GND IN48 \$61 GND nfet_03v3 L=0.28U W=0.44U AS=0.2684P AD=0.2684P PS=2.1U
+ PD=2.1U
* device instance $347 r0 *1 74.95,103.82 nfet_03v3
M$347 GND IN50 \$61 GND nfet_03v3 L=0.28U W=0.44U AS=0.2684P AD=0.2684P PS=2.1U
+ PD=2.1U
* device instance $348 r0 *1 74.95,102.18 nfet_03v3
M$348 GND IN51 \$61 GND nfet_03v3 L=0.28U W=0.44U AS=0.2684P AD=0.2684P PS=2.1U
+ PD=2.1U
* device instance $349 r0 *1 74.95,92.34 nfet_03v3
M$349 GND IN57 \$61 GND nfet_03v3 L=0.28U W=0.44U AS=0.2684P AD=0.2684P PS=2.1U
+ PD=2.1U
* device instance $350 r0 *1 74.95,93.98 nfet_03v3
M$350 GND IN56 \$61 GND nfet_03v3 L=0.28U W=0.44U AS=0.2684P AD=0.2684P PS=2.1U
+ PD=2.1U
* device instance $351 r0 *1 74.95,95.62 nfet_03v3
M$351 GND IN55 \$61 GND nfet_03v3 L=0.28U W=0.44U AS=0.2684P AD=0.2684P PS=2.1U
+ PD=2.1U
* device instance $352 r0 *1 74.95,90.7 nfet_03v3
M$352 GND IN58 \$61 GND nfet_03v3 L=0.28U W=0.44U AS=0.2684P AD=0.2684P PS=2.1U
+ PD=2.1U
* device instance $353 r0 *1 74.95,97.26 nfet_03v3
M$353 GND IN54 \$61 GND nfet_03v3 L=0.28U W=0.44U AS=0.2684P AD=0.2684P PS=2.1U
+ PD=2.1U
* device instance $354 r0 *1 74.95,108.74 nfet_03v3
M$354 GND IN47 \$61 GND nfet_03v3 L=0.28U W=0.44U AS=0.2684P AD=0.2684P PS=2.1U
+ PD=2.1U
* device instance $355 r0 *1 74.95,87.42 nfet_03v3
M$355 GND IN60 \$61 GND nfet_03v3 L=0.28U W=0.44U AS=0.2684P AD=0.2684P PS=2.1U
+ PD=2.1U
* device instance $356 r0 *1 74.95,98.9 nfet_03v3
M$356 GND IN53 \$61 GND nfet_03v3 L=0.28U W=0.44U AS=0.2684P AD=0.2684P PS=2.1U
+ PD=2.1U
* device instance $357 r0 *1 74.95,89.06 nfet_03v3
M$357 GND IN59 \$61 GND nfet_03v3 L=0.28U W=0.44U AS=0.2684P AD=0.2684P PS=2.1U
+ PD=2.1U
* device instance $358 r0 *1 74.95,85.78 nfet_03v3
M$358 GND IN61 \$61 GND nfet_03v3 L=0.28U W=0.44U AS=0.2684P AD=0.2684P PS=2.1U
+ PD=2.1U
* device instance $359 m90 *1 72.71,87.42 nfet_03v3
M$359 GND IN28 \$96 GND nfet_03v3 L=0.28U W=0.44U AS=0.2684P AD=0.2684P PS=2.1U
+ PD=2.1U
* device instance $360 m90 *1 67.97,87.42 nfet_03v3
M$360 GND IN28 \$72 GND nfet_03v3 L=0.28U W=0.44U AS=0.2684P AD=0.2684P PS=2.1U
+ PD=2.1U
* device instance $361 m90 *1 67.97,85.78 nfet_03v3
M$361 GND IN29 \$72 GND nfet_03v3 L=0.28U W=0.44U AS=0.2684P AD=0.2684P PS=2.1U
+ PD=2.1U
* device instance $362 r0 *1 79.69,87.42 nfet_03v3
M$362 GND IN60 \$79 GND nfet_03v3 L=0.28U W=0.44U AS=0.2684P AD=0.2684P PS=2.1U
+ PD=2.1U
* device instance $363 r0 *1 84.43,87.42 nfet_03v3
M$363 GND IN60 \$91 GND nfet_03v3 L=0.28U W=0.44U AS=0.2684P AD=0.2684P PS=2.1U
+ PD=2.1U
* device instance $364 r0 *1 79.69,85.78 nfet_03v3
M$364 GND IN61 \$79 GND nfet_03v3 L=0.28U W=0.44U AS=0.2684P AD=0.2684P PS=2.1U
+ PD=2.1U
* device instance $365 m90 *1 67.97,89.06 nfet_03v3
M$365 GND IN27 \$72 GND nfet_03v3 L=0.28U W=0.44U AS=0.2684P AD=0.2684P PS=2.1U
+ PD=2.1U
* device instance $366 m90 *1 67.97,100.54 nfet_03v3
M$366 GND IN20 \$72 GND nfet_03v3 L=0.28U W=0.44U AS=0.2684P AD=0.2684P PS=2.1U
+ PD=2.1U
* device instance $367 m90 *1 67.97,97.26 nfet_03v3
M$367 GND IN22 \$72 GND nfet_03v3 L=0.28U W=0.44U AS=0.2684P AD=0.2684P PS=2.1U
+ PD=2.1U
* device instance $368 m90 *1 67.97,98.9 nfet_03v3
M$368 GND IN21 \$72 GND nfet_03v3 L=0.28U W=0.44U AS=0.2684P AD=0.2684P PS=2.1U
+ PD=2.1U
* device instance $369 m90 *1 67.97,102.18 nfet_03v3
M$369 GND IN19 \$72 GND nfet_03v3 L=0.28U W=0.44U AS=0.2684P AD=0.2684P PS=2.1U
+ PD=2.1U
* device instance $370 m90 *1 67.97,123.5 nfet_03v3
M$370 GND IN6 \$72 GND nfet_03v3 L=0.28U W=0.44U AS=0.2684P AD=0.2684P PS=2.1U
+ PD=2.1U
* device instance $371 m90 *1 67.97,125.14 nfet_03v3
M$371 GND IN5 \$72 GND nfet_03v3 L=0.28U W=0.44U AS=0.2684P AD=0.2684P PS=2.1U
+ PD=2.1U
* device instance $372 m90 *1 67.97,110.38 nfet_03v3
M$372 GND IN14 \$72 GND nfet_03v3 L=0.28U W=0.44U AS=0.2684P AD=0.2684P PS=2.1U
+ PD=2.1U
* device instance $373 m90 *1 67.97,128.42 nfet_03v3
M$373 GND IN3 \$72 GND nfet_03v3 L=0.28U W=0.44U AS=0.2684P AD=0.2684P PS=2.1U
+ PD=2.1U
* device instance $374 m90 *1 67.97,115.3 nfet_03v3
M$374 GND IN11 \$72 GND nfet_03v3 L=0.28U W=0.44U AS=0.2684P AD=0.2684P PS=2.1U
+ PD=2.1U
* device instance $375 m90 *1 67.97,113.66 nfet_03v3
M$375 GND IN12 \$72 GND nfet_03v3 L=0.28U W=0.44U AS=0.2684P AD=0.2684P PS=2.1U
+ PD=2.1U
* device instance $376 m90 *1 67.97,112.02 nfet_03v3
M$376 GND IN13 \$72 GND nfet_03v3 L=0.28U W=0.44U AS=0.2684P AD=0.2684P PS=2.1U
+ PD=2.1U
* device instance $377 m90 *1 67.97,126.78 nfet_03v3
M$377 GND IN4 \$72 GND nfet_03v3 L=0.28U W=0.44U AS=0.2684P AD=0.2684P PS=2.1U
+ PD=2.1U
* device instance $378 r0 *1 79.69,89.06 nfet_03v3
M$378 GND IN59 \$79 GND nfet_03v3 L=0.28U W=0.44U AS=0.2684P AD=0.2684P PS=2.1U
+ PD=2.1U
* device instance $379 r0 *1 79.69,102.18 nfet_03v3
M$379 GND IN51 \$79 GND nfet_03v3 L=0.28U W=0.44U AS=0.2684P AD=0.2684P PS=2.1U
+ PD=2.1U
* device instance $380 r0 *1 79.69,97.26 nfet_03v3
M$380 GND IN54 \$79 GND nfet_03v3 L=0.28U W=0.44U AS=0.2684P AD=0.2684P PS=2.1U
+ PD=2.1U
* device instance $381 r0 *1 79.69,100.54 nfet_03v3
M$381 GND IN52 \$79 GND nfet_03v3 L=0.28U W=0.44U AS=0.2684P AD=0.2684P PS=2.1U
+ PD=2.1U
* device instance $382 r0 *1 79.69,98.9 nfet_03v3
M$382 GND IN53 \$79 GND nfet_03v3 L=0.28U W=0.44U AS=0.2684P AD=0.2684P PS=2.1U
+ PD=2.1U
* device instance $383 r0 *1 79.69,113.66 nfet_03v3
M$383 GND IN44 \$79 GND nfet_03v3 L=0.28U W=0.44U AS=0.2684P AD=0.2684P PS=2.1U
+ PD=2.1U
* device instance $384 r0 *1 79.69,115.3 nfet_03v3
M$384 GND IN43 \$79 GND nfet_03v3 L=0.28U W=0.44U AS=0.2684P AD=0.2684P PS=2.1U
+ PD=2.1U
* device instance $385 r0 *1 79.69,110.38 nfet_03v3
M$385 GND IN46 \$79 GND nfet_03v3 L=0.28U W=0.44U AS=0.2684P AD=0.2684P PS=2.1U
+ PD=2.1U
* device instance $386 r0 *1 79.69,123.5 nfet_03v3
M$386 GND IN38 \$79 GND nfet_03v3 L=0.28U W=0.44U AS=0.2684P AD=0.2684P PS=2.1U
+ PD=2.1U
* device instance $387 r0 *1 79.69,125.14 nfet_03v3
M$387 GND IN37 \$79 GND nfet_03v3 L=0.28U W=0.44U AS=0.2684P AD=0.2684P PS=2.1U
+ PD=2.1U
* device instance $388 r0 *1 79.69,126.78 nfet_03v3
M$388 GND IN36 \$79 GND nfet_03v3 L=0.28U W=0.44U AS=0.2684P AD=0.2684P PS=2.1U
+ PD=2.1U
* device instance $389 r0 *1 79.69,128.42 nfet_03v3
M$389 GND IN35 \$79 GND nfet_03v3 L=0.28U W=0.44U AS=0.2684P AD=0.2684P PS=2.1U
+ PD=2.1U
* device instance $390 r0 *1 79.69,112.02 nfet_03v3
M$390 GND IN45 \$79 GND nfet_03v3 L=0.28U W=0.44U AS=0.2684P AD=0.2684P PS=2.1U
+ PD=2.1U
* device instance $391 m90 *1 72.71,90.7 nfet_03v3
M$391 GND IN26 \$96 GND nfet_03v3 L=0.28U W=0.44U AS=0.2684P AD=0.2684P PS=2.1U
+ PD=2.1U
* device instance $392 r0 *1 84.43,126.78 nfet_03v3
M$392 GND IN36 \$91 GND nfet_03v3 L=0.28U W=0.44U AS=0.2684P AD=0.2684P PS=2.1U
+ PD=2.1U
* device instance $393 r0 *1 84.43,90.7 nfet_03v3
M$393 GND IN58 \$91 GND nfet_03v3 L=0.28U W=0.44U AS=0.2684P AD=0.2684P PS=2.1U
+ PD=2.1U
* device instance $394 r0 *1 84.43,100.54 nfet_03v3
M$394 GND IN52 \$91 GND nfet_03v3 L=0.28U W=0.44U AS=0.2684P AD=0.2684P PS=2.1U
+ PD=2.1U
* device instance $395 r0 *1 84.43,110.38 nfet_03v3
M$395 GND IN46 \$91 GND nfet_03v3 L=0.28U W=0.44U AS=0.2684P AD=0.2684P PS=2.1U
+ PD=2.1U
* device instance $396 r0 *1 84.43,103.82 nfet_03v3
M$396 GND IN50 \$91 GND nfet_03v3 L=0.28U W=0.44U AS=0.2684P AD=0.2684P PS=2.1U
+ PD=2.1U
* device instance $397 r0 *1 84.43,113.66 nfet_03v3
M$397 GND IN44 \$91 GND nfet_03v3 L=0.28U W=0.44U AS=0.2684P AD=0.2684P PS=2.1U
+ PD=2.1U
* device instance $398 r0 *1 84.43,107.1 nfet_03v3
M$398 GND IN48 \$91 GND nfet_03v3 L=0.28U W=0.44U AS=0.2684P AD=0.2684P PS=2.1U
+ PD=2.1U
* device instance $399 r0 *1 84.43,97.26 nfet_03v3
M$399 GND IN54 \$91 GND nfet_03v3 L=0.28U W=0.44U AS=0.2684P AD=0.2684P PS=2.1U
+ PD=2.1U
* device instance $400 r0 *1 84.43,93.98 nfet_03v3
M$400 GND IN56 \$91 GND nfet_03v3 L=0.28U W=0.44U AS=0.2684P AD=0.2684P PS=2.1U
+ PD=2.1U
* device instance $401 r0 *1 84.43,120.22 nfet_03v3
M$401 GND IN40 \$91 GND nfet_03v3 L=0.28U W=0.44U AS=0.2684P AD=0.2684P PS=2.1U
+ PD=2.1U
* device instance $402 r0 *1 84.43,123.5 nfet_03v3
M$402 GND IN38 \$91 GND nfet_03v3 L=0.28U W=0.44U AS=0.2684P AD=0.2684P PS=2.1U
+ PD=2.1U
* device instance $403 r0 *1 84.43,130.06 nfet_03v3
M$403 GND IN34 \$91 GND nfet_03v3 L=0.28U W=0.44U AS=0.2684P AD=0.2684P PS=2.1U
+ PD=2.1U
* device instance $404 r0 *1 84.43,116.94 nfet_03v3
M$404 GND IN42 \$91 GND nfet_03v3 L=0.28U W=0.44U AS=0.2684P AD=0.2684P PS=2.1U
+ PD=2.1U
* device instance $405 r0 *1 84.43,133.34 nfet_03v3
M$405 GND IN32 \$91 GND nfet_03v3 L=0.28U W=0.44U AS=0.2684P AD=0.2684P PS=2.1U
+ PD=2.1U
* device instance $406 m90 *1 72.71,120.22 nfet_03v3
M$406 GND IN8 \$96 GND nfet_03v3 L=0.28U W=0.44U AS=0.2684P AD=0.2684P PS=2.1U
+ PD=2.1U
* device instance $407 m90 *1 72.71,130.06 nfet_03v3
M$407 GND IN2 \$96 GND nfet_03v3 L=0.28U W=0.44U AS=0.2684P AD=0.2684P PS=2.1U
+ PD=2.1U
* device instance $408 m90 *1 72.71,100.54 nfet_03v3
M$408 GND IN20 \$96 GND nfet_03v3 L=0.28U W=0.44U AS=0.2684P AD=0.2684P PS=2.1U
+ PD=2.1U
* device instance $409 m90 *1 72.71,113.66 nfet_03v3
M$409 GND IN12 \$96 GND nfet_03v3 L=0.28U W=0.44U AS=0.2684P AD=0.2684P PS=2.1U
+ PD=2.1U
* device instance $410 m90 *1 72.71,116.94 nfet_03v3
M$410 GND IN10 \$96 GND nfet_03v3 L=0.28U W=0.44U AS=0.2684P AD=0.2684P PS=2.1U
+ PD=2.1U
* device instance $411 m90 *1 72.71,103.82 nfet_03v3
M$411 GND IN18 \$96 GND nfet_03v3 L=0.28U W=0.44U AS=0.2684P AD=0.2684P PS=2.1U
+ PD=2.1U
* device instance $412 m90 *1 72.71,110.38 nfet_03v3
M$412 GND IN14 \$96 GND nfet_03v3 L=0.28U W=0.44U AS=0.2684P AD=0.2684P PS=2.1U
+ PD=2.1U
* device instance $413 m90 *1 72.71,107.1 nfet_03v3
M$413 GND IN16 \$96 GND nfet_03v3 L=0.28U W=0.44U AS=0.2684P AD=0.2684P PS=2.1U
+ PD=2.1U
* device instance $414 m90 *1 72.71,97.26 nfet_03v3
M$414 GND IN22 \$96 GND nfet_03v3 L=0.28U W=0.44U AS=0.2684P AD=0.2684P PS=2.1U
+ PD=2.1U
* device instance $415 m90 *1 72.71,123.5 nfet_03v3
M$415 GND IN6 \$96 GND nfet_03v3 L=0.28U W=0.44U AS=0.2684P AD=0.2684P PS=2.1U
+ PD=2.1U
* device instance $416 m90 *1 72.71,126.78 nfet_03v3
M$416 GND IN4 \$96 GND nfet_03v3 L=0.28U W=0.44U AS=0.2684P AD=0.2684P PS=2.1U
+ PD=2.1U
* device instance $417 m90 *1 72.71,133.34 nfet_03v3
M$417 GND IN0 \$96 GND nfet_03v3 L=0.28U W=0.44U AS=0.2684P AD=0.2684P PS=2.1U
+ PD=2.1U
* device instance $418 m90 *1 72.71,93.98 nfet_03v3
M$418 GND IN24 \$96 GND nfet_03v3 L=0.28U W=0.44U AS=0.2684P AD=0.2684P PS=2.1U
+ PD=2.1U
* device instance $419 r90 *1 57.1,68.24 nfet_03v3
M$419 GND \$1 B0 GND nfet_03v3 L=0.28U W=0.44U AS=0.2684P AD=0.2684P PS=2.1U
+ PD=2.1U
* device instance $420 m45 *1 59.08,68.24 nfet_03v3
M$420 GND \$2 B1 GND nfet_03v3 L=0.28U W=0.44U AS=0.2684P AD=0.2684P PS=2.1U
+ PD=2.1U
* device instance $421 r270 *1 59.08,70.74 nfet_03v3
M$421 GND \$35 B3 GND nfet_03v3 L=0.28U W=0.44U AS=0.2684P AD=0.2684P PS=2.1U
+ PD=2.1U
* device instance $422 m135 *1 61.14,70.74 nfet_03v3
M$422 GND \$26 B2 GND nfet_03v3 L=0.28U W=0.44U AS=0.2684P AD=0.2684P PS=2.1U
+ PD=2.1U
* device instance $423 m135 *1 86.38,66.52 nfet_03v3
M$423 GND THERMOMETER_31 \$7 GND nfet_03v3 L=0.28U W=0.44U AS=0.2684P
+ AD=0.2684P PS=2.1U PD=2.1U
* device instance $424 m135 *1 57.1,70.74 nfet_03v3
M$424 GND \$43 B4 GND nfet_03v3 L=0.28U W=0.44U AS=0.2684P AD=0.2684P PS=2.1U
+ PD=2.1U
* device instance $425 m0 *1 74.76,62.29 pfet_03v3
M$425 \$1 \$7 \$96 VDD pfet_03v3 L=0.28U W=1.32U AS=0.5148P AD=0.5148P PS=4.1U
+ PD=4.1U
* device instance $428 r180 *1 82.38,62.29 pfet_03v3
M$428 \$1 THERMOMETER_31 \$91 VDD pfet_03v3 L=0.28U W=1.32U AS=0.5148P
+ AD=0.5148P PS=4.1U PD=4.1U
* device instance $431 m0 *1 72.39,66.63 pfet_03v3
M$431 \$2 \$7 \$16 VDD pfet_03v3 L=0.28U W=1.32U AS=0.5148P AD=0.5148P PS=4.1U
+ PD=4.1U
* device instance $434 r180 *1 80.01,66.63 pfet_03v3
M$434 \$2 THERMOMETER_31 \$17 VDD pfet_03v3 L=0.28U W=1.32U AS=0.5148P
+ AD=0.5148P PS=4.1U PD=4.1U
* device instance $437 m0 *1 65.28,79.65 pfet_03v3
M$437 \$43 \$7 \$59 VDD pfet_03v3 L=0.28U W=1.32U AS=0.5148P AD=0.5148P PS=4.1U
+ PD=4.1U
* device instance $440 r180 *1 72.9,79.65 pfet_03v3
M$440 \$43 THERMOMETER_31 \$61 VDD pfet_03v3 L=0.28U W=1.32U AS=0.5148P
+ AD=0.5148P PS=4.1U PD=4.1U
* device instance $443 m0 *1 70.02,70.97 pfet_03v3
M$443 \$26 \$7 \$72 VDD pfet_03v3 L=0.28U W=1.32U AS=0.5148P AD=0.5148P PS=4.1U
+ PD=4.1U
* device instance $446 r180 *1 77.64,70.97 pfet_03v3
M$446 \$26 THERMOMETER_31 \$79 VDD pfet_03v3 L=0.28U W=1.32U AS=0.5148P
+ AD=0.5148P PS=4.1U PD=4.1U
* device instance $449 m0 *1 67.65,75.31 pfet_03v3
M$449 \$35 \$7 \$36 VDD pfet_03v3 L=0.28U W=1.32U AS=0.5148P AD=0.5148P PS=4.1U
+ PD=4.1U
* device instance $452 r180 *1 75.27,75.31 pfet_03v3
M$452 \$35 THERMOMETER_31 \$37 VDD pfet_03v3 L=0.28U W=1.32U AS=0.5148P
+ AD=0.5148P PS=4.1U PD=4.1U
* device instance $455 m90 *1 71.96,62.29 nfet_03v3
M$455 \$1 THERMOMETER_31 \$96 GND nfet_03v3 L=0.28U W=0.44U AS=0.2684P
+ AD=0.2684P PS=2.1U PD=2.1U
* device instance $456 r0 *1 85.18,62.29 nfet_03v3
M$456 \$1 \$7 \$91 GND nfet_03v3 L=0.28U W=0.44U AS=0.2684P AD=0.2684P PS=2.1U
+ PD=2.1U
* device instance $457 m90 *1 69.59,66.63 nfet_03v3
M$457 \$2 THERMOMETER_31 \$16 GND nfet_03v3 L=0.28U W=0.44U AS=0.2684P
+ AD=0.2684P PS=2.1U PD=2.1U
* device instance $458 r0 *1 82.81,66.63 nfet_03v3
M$458 \$2 \$7 \$17 GND nfet_03v3 L=0.28U W=0.44U AS=0.2684P AD=0.2684P PS=2.1U
+ PD=2.1U
* device instance $459 m90 *1 62.48,79.65 nfet_03v3
M$459 \$43 THERMOMETER_31 \$59 GND nfet_03v3 L=0.28U W=0.44U AS=0.2684P
+ AD=0.2684P PS=2.1U PD=2.1U
* device instance $460 r0 *1 75.7,79.65 nfet_03v3
M$460 \$43 \$7 \$61 GND nfet_03v3 L=0.28U W=0.44U AS=0.2684P AD=0.2684P PS=2.1U
+ PD=2.1U
* device instance $461 m90 *1 67.22,70.97 nfet_03v3
M$461 \$26 THERMOMETER_31 \$72 GND nfet_03v3 L=0.28U W=0.44U AS=0.2684P
+ AD=0.2684P PS=2.1U PD=2.1U
* device instance $462 r0 *1 80.44,70.97 nfet_03v3
M$462 \$26 \$7 \$79 GND nfet_03v3 L=0.28U W=0.44U AS=0.2684P AD=0.2684P PS=2.1U
+ PD=2.1U
* device instance $463 m90 *1 64.85,75.31 nfet_03v3
M$463 \$35 THERMOMETER_31 \$36 GND nfet_03v3 L=0.28U W=0.44U AS=0.2684P
+ AD=0.2684P PS=2.1U PD=2.1U
* device instance $464 r0 *1 78.07,75.31 nfet_03v3
M$464 \$35 \$7 \$37 GND nfet_03v3 L=0.28U W=0.44U AS=0.2684P AD=0.2684P PS=2.1U
+ PD=2.1U
.ENDS rom2
