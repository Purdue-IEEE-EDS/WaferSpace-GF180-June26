* Extracted by KLayout with GF180MCU LVS runset on : 03/07/2026 04:47

.SUBCKT rom2 GND VDD
+ THEMOMETER_32\x20also\x20acts\x20as\x20OUTPUT_5\x20\x28highest\x20bit\x20of\x20output\x29.|THERMOMETER_32
+ ONEHOT_31 ONEHOT_63 ONEHOT_30 ONEHOT_62 ONEHOT_29 ONEHOT_61 ONEHOT_28
+ ONEHOT_60 ONEHOT_27 ONEHOT_59 ONEHOT_26 ONEHOT_58 ONEHOT_25 ONEHOT_57
+ ONEHOT_24 ONEHOT_56 ONEHOT_23 ONEHOT_55 ONEHOT_22 ONEHOT_54 ONEHOT_21
+ ONEHOT_53 ONEHOT_20 ONEHOT_52 ONEHOT_19 ONEHOT_51 ONEHOT_18 ONEHOT_50
+ ONEHOT_17 ONEHOT_49 ONEHOT_16 ONEHOT_48 ONEHOT_14 ONEHOT_15 ONEHOT_46
+ ONEHOT_47 ONEHOT_13 ONEHOT_45 ONEHOT_12 ONEHOT_44 ONEHOT_11 ONEHOT_43
+ ONEHOT_10 ONEHOT_42 ONEHOT_9 ONEHOT_41 ONEHOT_8 ONEHOT_40 ONEHOT_6 ONEHOT_7
+ ONEHOT_38 ONEHOT_39 ONEHOT_5 ONEHOT_37 ONEHOT_4 ONEHOT_36 ONEHOT_3 ONEHOT_35
+ ONEHOT_2 ONEHOT_34 ONEHOT_1 ONEHOT_33
M$1 \$8 \$5 VDD VDD pfet_03v3 L=0.28U W=1.32U AS=0.5148P AD=0.5148P PS=4.1U
+ PD=4.1U
M$4 VDD
+ THEMOMETER_32\x20also\x20acts\x20as\x20OUTPUT_5\x20\x28highest\x20bit\x20of\x20output\x29.|THERMOMETER_32
+ \$4 VDD pfet_03v3 L=0.28U W=1.32U AS=0.5148P AD=0.5148P PS=4.1U PD=4.1U
M$7 VDD \$11 \$10 VDD pfet_03v3 L=0.28U W=1.32U AS=0.5148P AD=0.5148P PS=4.1U
+ PD=4.1U
M$10 \$21
+ THEMOMETER_32\x20also\x20acts\x20as\x20OUTPUT_5\x20\x28highest\x20bit\x20of\x20output\x29.|THERMOMETER_32
+ VDD VDD pfet_03v3 L=0.28U W=1.32U AS=0.5148P AD=0.5148P PS=4.1U PD=4.1U
M$13 VDD
+ THEMOMETER_32\x20also\x20acts\x20as\x20OUTPUT_5\x20\x28highest\x20bit\x20of\x20output\x29.|THERMOMETER_32
+ \$23 VDD pfet_03v3 L=0.28U W=1.32U AS=0.5148P AD=0.5148P PS=4.1U PD=4.1U
M$16 \$24 \$4 VDD VDD pfet_03v3 L=0.28U W=1.32U AS=0.5148P AD=0.5148P PS=4.1U
+ PD=4.1U
M$19 VDD \$4 \$26 VDD pfet_03v3 L=0.28U W=1.32U AS=0.5148P AD=0.5148P PS=4.1U
+ PD=4.1U
M$22 \$32 \$33 VDD VDD pfet_03v3 L=0.28U W=1.32U AS=0.5148P AD=0.5148P PS=4.1U
+ PD=4.1U
M$25 \$11 \$21 \$35 VDD pfet_03v3 L=0.28U W=1.32U AS=0.5148P AD=0.5148P PS=4.1U
+ PD=4.1U
M$28 \$36 \$23 \$5 VDD pfet_03v3 L=0.28U W=1.32U AS=0.5148P AD=0.5148P PS=4.1U
+ PD=4.1U
M$31 \$5 \$24 \$37 VDD pfet_03v3 L=0.28U W=1.32U AS=0.5148P AD=0.5148P PS=4.1U
+ PD=4.1U
M$34 \$39 \$26 \$38 VDD pfet_03v3 L=0.28U W=1.32U AS=0.5148P AD=0.5148P PS=4.1U
+ PD=4.1U
M$37 \$57
+ THEMOMETER_32\x20also\x20acts\x20as\x20OUTPUT_5\x20\x28highest\x20bit\x20of\x20output\x29.|THERMOMETER_32
+ VDD VDD pfet_03v3 L=0.28U W=1.32U AS=0.5148P AD=0.5148P PS=4.1U PD=4.1U
M$40 VDD
+ THEMOMETER_32\x20also\x20acts\x20as\x20OUTPUT_5\x20\x28highest\x20bit\x20of\x20output\x29.|THERMOMETER_32
+ \$59 VDD pfet_03v3 L=0.28U W=1.32U AS=0.5148P AD=0.5148P PS=4.1U PD=4.1U
M$43 \$60 \$4 VDD VDD pfet_03v3 L=0.28U W=1.32U AS=0.5148P AD=0.5148P PS=4.1U
+ PD=4.1U
M$46 VDD \$4 \$62 VDD pfet_03v3 L=0.28U W=1.32U AS=0.5148P AD=0.5148P PS=4.1U
+ PD=4.1U
M$49 VDD \$48 \$47 VDD pfet_03v3 L=0.28U W=1.32U AS=0.5148P AD=0.5148P PS=4.1U
+ PD=4.1U
M$52 \$48 \$57 \$71 VDD pfet_03v3 L=0.28U W=1.32U AS=0.5148P AD=0.5148P PS=4.1U
+ PD=4.1U
M$55 \$72 \$59 \$33 VDD pfet_03v3 L=0.28U W=1.32U AS=0.5148P AD=0.5148P PS=4.1U
+ PD=4.1U
M$58 \$33 \$60 \$73 VDD pfet_03v3 L=0.28U W=1.32U AS=0.5148P AD=0.5148P PS=4.1U
+ PD=4.1U
M$61 \$74 \$62 \$11 VDD pfet_03v3 L=0.28U W=1.32U AS=0.5148P AD=0.5148P PS=4.1U
+ PD=4.1U
M$64 \$69 \$70 VDD VDD pfet_03v3 L=0.28U W=1.32U AS=0.5148P AD=0.5148P PS=4.1U
+ PD=4.1U
M$67 \$84
+ THEMOMETER_32\x20also\x20acts\x20as\x20OUTPUT_5\x20\x28highest\x20bit\x20of\x20output\x29.|THERMOMETER_32
+ VDD VDD pfet_03v3 L=0.28U W=1.32U AS=0.5148P AD=0.5148P PS=4.1U PD=4.1U
M$70 VDD
+ THEMOMETER_32\x20also\x20acts\x20as\x20OUTPUT_5\x20\x28highest\x20bit\x20of\x20output\x29.|THERMOMETER_32
+ \$86 VDD pfet_03v3 L=0.28U W=1.32U AS=0.5148P AD=0.5148P PS=4.1U PD=4.1U
M$73 \$87 \$4 VDD VDD pfet_03v3 L=0.28U W=1.32U AS=0.5148P AD=0.5148P PS=4.1U
+ PD=4.1U
M$76 VDD \$4 \$89 VDD pfet_03v3 L=0.28U W=1.32U AS=0.5148P AD=0.5148P PS=4.1U
+ PD=4.1U
M$79 \$91 \$84 \$90 VDD pfet_03v3 L=0.28U W=1.32U AS=0.5148P AD=0.5148P PS=4.1U
+ PD=4.1U
M$82 \$92 \$86 \$70 VDD pfet_03v3 L=0.28U W=1.32U AS=0.5148P AD=0.5148P PS=4.1U
+ PD=4.1U
M$85 \$70 \$87 \$93 VDD pfet_03v3 L=0.28U W=1.32U AS=0.5148P AD=0.5148P PS=4.1U
+ PD=4.1U
M$88 \$94 \$89 \$48 VDD pfet_03v3 L=0.28U W=1.32U AS=0.5148P AD=0.5148P PS=4.1U
+ PD=4.1U
M$91 \$4
+ THEMOMETER_32\x20also\x20acts\x20as\x20OUTPUT_5\x20\x28highest\x20bit\x20of\x20output\x29.|THERMOMETER_32
+ GND GND nfet_03v3 L=0.28U W=0.44U AS=0.2684P AD=0.2684P PS=2.1U PD=2.1U
M$92 \$10 \$11 GND GND nfet_03v3 L=0.28U W=0.44U AS=0.2684P AD=0.2684P PS=2.1U
+ PD=2.1U
M$93 GND \$5 \$8 GND nfet_03v3 L=0.28U W=0.44U AS=0.2684P AD=0.2684P PS=2.1U
+ PD=2.1U
M$94 GND
+ THEMOMETER_32\x20also\x20acts\x20as\x20OUTPUT_5\x20\x28highest\x20bit\x20of\x20output\x29.|THERMOMETER_32
+ \$21 GND nfet_03v3 L=0.28U W=0.44U AS=0.2684P AD=0.2684P PS=2.1U PD=2.1U
M$95 \$23
+ THEMOMETER_32\x20also\x20acts\x20as\x20OUTPUT_5\x20\x28highest\x20bit\x20of\x20output\x29.|THERMOMETER_32
+ GND GND nfet_03v3 L=0.28U W=0.44U AS=0.2684P AD=0.2684P PS=2.1U PD=2.1U
M$96 GND \$4 \$24 GND nfet_03v3 L=0.28U W=0.44U AS=0.2684P AD=0.2684P PS=2.1U
+ PD=2.1U
M$97 \$26 \$4 GND GND nfet_03v3 L=0.28U W=0.44U AS=0.2684P AD=0.2684P PS=2.1U
+ PD=2.1U
M$98 \$11
+ THEMOMETER_32\x20also\x20acts\x20as\x20OUTPUT_5\x20\x28highest\x20bit\x20of\x20output\x29.|THERMOMETER_32
+ \$35 GND nfet_03v3 L=0.28U W=0.44U AS=0.2684P AD=0.2684P PS=2.1U PD=2.1U
M$99 \$36
+ THEMOMETER_32\x20also\x20acts\x20as\x20OUTPUT_5\x20\x28highest\x20bit\x20of\x20output\x29.|THERMOMETER_32
+ \$5 GND nfet_03v3 L=0.28U W=0.44U AS=0.2684P AD=0.2684P PS=2.1U PD=2.1U
M$100 \$5 \$4 \$37 GND nfet_03v3 L=0.28U W=0.44U AS=0.2684P AD=0.2684P PS=2.1U
+ PD=2.1U
M$101 \$39 \$4 \$38 GND nfet_03v3 L=0.28U W=0.44U AS=0.2684P AD=0.2684P PS=2.1U
+ PD=2.1U
M$102 \$47 \$48 \$34 GND nfet_03v3 L=0.28U W=0.44U AS=0.2684P AD=0.2684P
+ PS=2.1U PD=2.1U
M$103 GND \$33 \$32 GND nfet_03v3 L=0.28U W=0.44U AS=0.2684P AD=0.2684P PS=2.1U
+ PD=2.1U
M$104 GND
+ THEMOMETER_32\x20also\x20acts\x20as\x20OUTPUT_5\x20\x28highest\x20bit\x20of\x20output\x29.|THERMOMETER_32
+ \$57 GND nfet_03v3 L=0.28U W=0.44U AS=0.2684P AD=0.2684P PS=2.1U PD=2.1U
M$105 \$59
+ THEMOMETER_32\x20also\x20acts\x20as\x20OUTPUT_5\x20\x28highest\x20bit\x20of\x20output\x29.|THERMOMETER_32
+ GND GND nfet_03v3 L=0.28U W=0.44U AS=0.2684P AD=0.2684P PS=2.1U PD=2.1U
M$106 GND \$4 \$60 GND nfet_03v3 L=0.28U W=0.44U AS=0.2684P AD=0.2684P PS=2.1U
+ PD=2.1U
M$107 \$62 \$4 GND GND nfet_03v3 L=0.28U W=0.44U AS=0.2684P AD=0.2684P PS=2.1U
+ PD=2.1U
M$108 GND
+ THEMOMETER_32\x20also\x20acts\x20as\x20OUTPUT_5\x20\x28highest\x20bit\x20of\x20output\x29.|THERMOMETER_32
+ \$84 GND nfet_03v3 L=0.28U W=0.44U AS=0.2684P AD=0.2684P PS=2.1U PD=2.1U
M$109 \$86
+ THEMOMETER_32\x20also\x20acts\x20as\x20OUTPUT_5\x20\x28highest\x20bit\x20of\x20output\x29.|THERMOMETER_32
+ GND GND nfet_03v3 L=0.28U W=0.44U AS=0.2684P AD=0.2684P PS=2.1U PD=2.1U
M$110 \$48
+ THEMOMETER_32\x20also\x20acts\x20as\x20OUTPUT_5\x20\x28highest\x20bit\x20of\x20output\x29.|THERMOMETER_32
+ \$71 GND nfet_03v3 L=0.28U W=0.44U AS=0.2684P AD=0.2684P PS=2.1U PD=2.1U
M$111 \$72
+ THEMOMETER_32\x20also\x20acts\x20as\x20OUTPUT_5\x20\x28highest\x20bit\x20of\x20output\x29.|THERMOMETER_32
+ \$33 GND nfet_03v3 L=0.28U W=0.44U AS=0.2684P AD=0.2684P PS=2.1U PD=2.1U
M$112 GND \$4 \$87 GND nfet_03v3 L=0.28U W=0.44U AS=0.2684P AD=0.2684P PS=2.1U
+ PD=2.1U
M$113 \$89 \$4 GND GND nfet_03v3 L=0.28U W=0.44U AS=0.2684P AD=0.2684P PS=2.1U
+ PD=2.1U
M$114 \$33 \$4 \$73 GND nfet_03v3 L=0.28U W=0.44U AS=0.2684P AD=0.2684P PS=2.1U
+ PD=2.1U
M$115 \$74 \$4 \$11 GND nfet_03v3 L=0.28U W=0.44U AS=0.2684P AD=0.2684P PS=2.1U
+ PD=2.1U
M$116 \$91
+ THEMOMETER_32\x20also\x20acts\x20as\x20OUTPUT_5\x20\x28highest\x20bit\x20of\x20output\x29.|THERMOMETER_32
+ \$90 GND nfet_03v3 L=0.28U W=0.44U AS=0.2684P AD=0.2684P PS=2.1U PD=2.1U
M$117 \$92
+ THEMOMETER_32\x20also\x20acts\x20as\x20OUTPUT_5\x20\x28highest\x20bit\x20of\x20output\x29.|THERMOMETER_32
+ \$70 GND nfet_03v3 L=0.28U W=0.44U AS=0.2684P AD=0.2684P PS=2.1U PD=2.1U
M$118 \$70 \$4 \$93 GND nfet_03v3 L=0.28U W=0.44U AS=0.2684P AD=0.2684P PS=2.1U
+ PD=2.1U
M$119 \$94 \$4 \$48 GND nfet_03v3 L=0.28U W=0.44U AS=0.2684P AD=0.2684P PS=2.1U
+ PD=2.1U
M$120 GND \$70 \$69 GND nfet_03v3 L=0.28U W=0.44U AS=0.2684P AD=0.2684P PS=2.1U
+ PD=2.1U
M$121 \$112 \$171 \$109 GND nfet_03v3 L=0.28U W=0.44U AS=0.2684P AD=0.2684P
+ PS=2.1U PD=2.1U
M$122 \$121 \$174 \$117 GND nfet_03v3 L=0.28U W=0.44U AS=0.2684P AD=0.2684P
+ PS=2.1U PD=2.1U
M$123 \$127 \$175 \$124 GND nfet_03v3 L=0.28U W=0.44U AS=0.2684P AD=0.2684P
+ PS=2.1U PD=2.1U
M$124 \$135 \$176 \$130 GND nfet_03v3 L=0.28U W=0.44U AS=0.2684P AD=0.2684P
+ PS=2.1U PD=2.1U
M$125 \$142 \$179 \$140 GND nfet_03v3 L=0.28U W=0.44U AS=0.2684P AD=0.2684P
+ PS=2.1U PD=2.1U
M$126 \$151 \$180 \$144 GND nfet_03v3 L=0.28U W=0.44U AS=0.2684P AD=0.2684P
+ PS=2.1U PD=2.1U
M$127 \$155 \$182 \$154 GND nfet_03v3 L=0.28U W=0.44U AS=0.2684P AD=0.2684P
+ PS=2.1U PD=2.1U
M$128 \$164 \$181 \$159 GND nfet_03v3 L=0.28U W=0.44U AS=0.2684P AD=0.2684P
+ PS=2.1U PD=2.1U
M$129 \$150 \$178 \$163 GND nfet_03v3 L=0.28U W=0.44U AS=0.2684P AD=0.2684P
+ PS=2.1U PD=2.1U
M$130 \$132 \$177 \$137 GND nfet_03v3 L=0.28U W=0.44U AS=0.2684P AD=0.2684P
+ PS=2.1U PD=2.1U
M$131 \$114 \$173 \$122 GND nfet_03v3 L=0.28U W=0.44U AS=0.2684P AD=0.2684P
+ PS=2.1U PD=2.1U
M$132 \$103 \$172 \$107 GND nfet_03v3 L=0.28U W=0.44U AS=0.2684P AD=0.2684P
+ PS=2.1U PD=2.1U
M$133 \$188 \$187 \$186 GND nfet_03v3 L=0.28U W=0.44U AS=0.2684P AD=0.2684P
+ PS=2.1U PD=2.1U
M$134 \$205 \$200 \$201 GND nfet_03v3 L=0.28U W=0.44U AS=0.2684P AD=0.2684P
+ PS=2.1U PD=2.1U
M$135 \$92 ONEHOT_31 GND GND nfet_03v3 L=0.28U W=0.44U AS=0.2684P AD=0.2684P
+ PS=2.1U PD=2.1U
M$136 \$92 ONEHOT_30 GND GND nfet_03v3 L=0.28U W=0.44U AS=0.2684P AD=0.2684P
+ PS=2.1U PD=2.1U
M$137 GND ONEHOT_30 \$71 GND nfet_03v3 L=0.28U W=0.44U AS=0.2684P AD=0.2684P
+ PS=2.1U PD=2.1U
M$138 GND ONEHOT_31 \$71 GND nfet_03v3 L=0.28U W=0.44U AS=0.2684P AD=0.2684P
+ PS=2.1U PD=2.1U
M$139 \$72 ONEHOT_31 GND GND nfet_03v3 L=0.28U W=0.44U AS=0.2684P AD=0.2684P
+ PS=2.1U PD=2.1U
M$140 \$72 ONEHOT_30 GND GND nfet_03v3 L=0.28U W=0.44U AS=0.2684P AD=0.2684P
+ PS=2.1U PD=2.1U
M$141 GND ONEHOT_30 \$35 GND nfet_03v3 L=0.28U W=0.44U AS=0.2684P AD=0.2684P
+ PS=2.1U PD=2.1U
M$142 GND ONEHOT_31 \$35 GND nfet_03v3 L=0.28U W=0.44U AS=0.2684P AD=0.2684P
+ PS=2.1U PD=2.1U
M$143 \$36 ONEHOT_31 GND GND nfet_03v3 L=0.28U W=0.44U AS=0.2684P AD=0.2684P
+ PS=2.1U PD=2.1U
M$144 \$218 \$217 \$216 GND nfet_03v3 L=0.28U W=0.44U AS=0.2684P AD=0.2684P
+ PS=2.1U PD=2.1U
M$145 GND ONEHOT_62 \$93 GND nfet_03v3 L=0.28U W=0.44U AS=0.2684P AD=0.2684P
+ PS=2.1U PD=2.1U
M$146 GND ONEHOT_63 \$93 GND nfet_03v3 L=0.28U W=0.44U AS=0.2684P AD=0.2684P
+ PS=2.1U PD=2.1U
M$147 \$94 ONEHOT_62 GND GND nfet_03v3 L=0.28U W=0.44U AS=0.2684P AD=0.2684P
+ PS=2.1U PD=2.1U
M$148 \$94 ONEHOT_63 GND GND nfet_03v3 L=0.28U W=0.44U AS=0.2684P AD=0.2684P
+ PS=2.1U PD=2.1U
M$149 GND ONEHOT_63 \$73 GND nfet_03v3 L=0.28U W=0.44U AS=0.2684P AD=0.2684P
+ PS=2.1U PD=2.1U
M$150 GND ONEHOT_62 \$73 GND nfet_03v3 L=0.28U W=0.44U AS=0.2684P AD=0.2684P
+ PS=2.1U PD=2.1U
M$151 \$74 ONEHOT_62 GND GND nfet_03v3 L=0.28U W=0.44U AS=0.2684P AD=0.2684P
+ PS=2.1U PD=2.1U
M$152 \$74 ONEHOT_63 GND GND nfet_03v3 L=0.28U W=0.44U AS=0.2684P AD=0.2684P
+ PS=2.1U PD=2.1U
M$153 GND ONEHOT_63 \$37 GND nfet_03v3 L=0.28U W=0.44U AS=0.2684P AD=0.2684P
+ PS=2.1U PD=2.1U
M$154 \$208 \$211 \$209 GND nfet_03v3 L=0.28U W=0.44U AS=0.2684P AD=0.2684P
+ PS=2.1U PD=2.1U
M$155 \$202 \$203 \$207 GND nfet_03v3 L=0.28U W=0.44U AS=0.2684P AD=0.2684P
+ PS=2.1U PD=2.1U
M$156 \$189 \$193 \$192 GND nfet_03v3 L=0.28U W=0.44U AS=0.2684P AD=0.2684P
+ PS=2.1U PD=2.1U
M$157 \$226 \$221 \$223 GND nfet_03v3 L=0.28U W=0.44U AS=0.2684P AD=0.2684P
+ PS=2.1U PD=2.1U
M$158 \$92 ONEHOT_29 GND GND nfet_03v3 L=0.28U W=0.44U AS=0.2684P AD=0.2684P
+ PS=2.1U PD=2.1U
M$159 GND ONEHOT_29 \$71 GND nfet_03v3 L=0.28U W=0.44U AS=0.2684P AD=0.2684P
+ PS=2.1U PD=2.1U
M$160 \$72 ONEHOT_29 GND GND nfet_03v3 L=0.28U W=0.44U AS=0.2684P AD=0.2684P
+ PS=2.1U PD=2.1U
M$161 \$236 \$235 \$234 GND nfet_03v3 L=0.28U W=0.44U AS=0.2684P AD=0.2684P
+ PS=2.1U PD=2.1U
M$162 \$36 ONEHOT_29 GND GND nfet_03v3 L=0.28U W=0.44U AS=0.2684P AD=0.2684P
+ PS=2.1U PD=2.1U
M$163 GND ONEHOT_61 \$93 GND nfet_03v3 L=0.28U W=0.44U AS=0.2684P AD=0.2684P
+ PS=2.1U PD=2.1U
M$164 \$94 ONEHOT_61 GND GND nfet_03v3 L=0.28U W=0.44U AS=0.2684P AD=0.2684P
+ PS=2.1U PD=2.1U
M$165 GND ONEHOT_61 \$73 GND nfet_03v3 L=0.28U W=0.44U AS=0.2684P AD=0.2684P
+ PS=2.1U PD=2.1U
M$166 \$229 \$230 \$231 GND nfet_03v3 L=0.28U W=0.44U AS=0.2684P AD=0.2684P
+ PS=2.1U PD=2.1U
M$167 GND ONEHOT_61 \$37 GND nfet_03v3 L=0.28U W=0.44U AS=0.2684P AD=0.2684P
+ PS=2.1U PD=2.1U
M$168 \$222 \$224 \$227 GND nfet_03v3 L=0.28U W=0.44U AS=0.2684P AD=0.2684P
+ PS=2.1U PD=2.1U
M$169 \$245 \$241 \$242 GND nfet_03v3 L=0.28U W=0.44U AS=0.2684P AD=0.2684P
+ PS=2.1U PD=2.1U
M$170 \$92 ONEHOT_28 GND GND nfet_03v3 L=0.28U W=0.44U AS=0.2684P AD=0.2684P
+ PS=2.1U PD=2.1U
M$171 GND ONEHOT_28 \$71 GND nfet_03v3 L=0.28U W=0.44U AS=0.2684P AD=0.2684P
+ PS=2.1U PD=2.1U
M$172 \$72 ONEHOT_28 GND GND nfet_03v3 L=0.28U W=0.44U AS=0.2684P AD=0.2684P
+ PS=2.1U PD=2.1U
M$173 \$261 \$260 \$259 GND nfet_03v3 L=0.28U W=0.44U AS=0.2684P AD=0.2684P
+ PS=2.1U PD=2.1U
M$174 \$266 \$265 \$262 GND nfet_03v3 L=0.28U W=0.44U AS=0.2684P AD=0.2684P
+ PS=2.1U PD=2.1U
M$175 GND ONEHOT_60 \$93 GND nfet_03v3 L=0.28U W=0.44U AS=0.2684P AD=0.2684P
+ PS=2.1U PD=2.1U
M$176 \$94 ONEHOT_60 GND GND nfet_03v3 L=0.28U W=0.44U AS=0.2684P AD=0.2684P
+ PS=2.1U PD=2.1U
M$177 GND ONEHOT_60 \$73 GND nfet_03v3 L=0.28U W=0.44U AS=0.2684P AD=0.2684P
+ PS=2.1U PD=2.1U
M$178 \$253 \$254 \$255 GND nfet_03v3 L=0.28U W=0.44U AS=0.2684P AD=0.2684P
+ PS=2.1U PD=2.1U
M$179 \$249 \$252 \$250 GND nfet_03v3 L=0.28U W=0.44U AS=0.2684P AD=0.2684P
+ PS=2.1U PD=2.1U
M$180 \$243 \$244 \$246 GND nfet_03v3 L=0.28U W=0.44U AS=0.2684P AD=0.2684P
+ PS=2.1U PD=2.1U
M$181 \$273 \$269 \$271 GND nfet_03v3 L=0.28U W=0.44U AS=0.2684P AD=0.2684P
+ PS=2.1U PD=2.1U
M$182 \$92 ONEHOT_27 GND GND nfet_03v3 L=0.28U W=0.44U AS=0.2684P AD=0.2684P
+ PS=2.1U PD=2.1U
M$183 GND ONEHOT_27 \$71 GND nfet_03v3 L=0.28U W=0.44U AS=0.2684P AD=0.2684P
+ PS=2.1U PD=2.1U
M$184 \$282 \$281 \$279 GND nfet_03v3 L=0.28U W=0.44U AS=0.2684P AD=0.2684P
+ PS=2.1U PD=2.1U
M$185 GND ONEHOT_27 \$35 GND nfet_03v3 L=0.28U W=0.44U AS=0.2684P AD=0.2684P
+ PS=2.1U PD=2.1U
M$186 \$36 ONEHOT_27 GND GND nfet_03v3 L=0.28U W=0.44U AS=0.2684P AD=0.2684P
+ PS=2.1U PD=2.1U
M$187 GND ONEHOT_59 \$93 GND nfet_03v3 L=0.28U W=0.44U AS=0.2684P AD=0.2684P
+ PS=2.1U PD=2.1U
M$188 \$94 ONEHOT_59 GND GND nfet_03v3 L=0.28U W=0.44U AS=0.2684P AD=0.2684P
+ PS=2.1U PD=2.1U
M$189 \$280 \$283 \$284 GND nfet_03v3 L=0.28U W=0.44U AS=0.2684P AD=0.2684P
+ PS=2.1U PD=2.1U
M$190 \$74 ONEHOT_59 GND GND nfet_03v3 L=0.28U W=0.44U AS=0.2684P AD=0.2684P
+ PS=2.1U PD=2.1U
M$191 GND ONEHOT_59 \$37 GND nfet_03v3 L=0.28U W=0.44U AS=0.2684P AD=0.2684P
+ PS=2.1U PD=2.1U
M$192 \$270 \$272 \$274 GND nfet_03v3 L=0.28U W=0.44U AS=0.2684P AD=0.2684P
+ PS=2.1U PD=2.1U
M$193 \$293 \$289 \$291 GND nfet_03v3 L=0.28U W=0.44U AS=0.2684P AD=0.2684P
+ PS=2.1U PD=2.1U
M$194 \$92 ONEHOT_26 GND GND nfet_03v3 L=0.28U W=0.44U AS=0.2684P AD=0.2684P
+ PS=2.1U PD=2.1U
M$195 GND ONEHOT_26 \$71 GND nfet_03v3 L=0.28U W=0.44U AS=0.2684P AD=0.2684P
+ PS=2.1U PD=2.1U
M$196 \$308 \$307 \$303 GND nfet_03v3 L=0.28U W=0.44U AS=0.2684P AD=0.2684P
+ PS=2.1U PD=2.1U
M$197 GND ONEHOT_26 \$35 GND nfet_03v3 L=0.28U W=0.44U AS=0.2684P AD=0.2684P
+ PS=2.1U PD=2.1U
M$198 \$313 \$312 \$310 GND nfet_03v3 L=0.28U W=0.44U AS=0.2684P AD=0.2684P
+ PS=2.1U PD=2.1U
M$199 GND ONEHOT_58 \$93 GND nfet_03v3 L=0.28U W=0.44U AS=0.2684P AD=0.2684P
+ PS=2.1U PD=2.1U
M$200 \$94 ONEHOT_58 GND GND nfet_03v3 L=0.28U W=0.44U AS=0.2684P AD=0.2684P
+ PS=2.1U PD=2.1U
M$201 \$302 \$305 \$306 GND nfet_03v3 L=0.28U W=0.44U AS=0.2684P AD=0.2684P
+ PS=2.1U PD=2.1U
M$202 \$74 ONEHOT_58 GND GND nfet_03v3 L=0.28U W=0.44U AS=0.2684P AD=0.2684P
+ PS=2.1U PD=2.1U
M$203 \$297 \$298 \$299 GND nfet_03v3 L=0.28U W=0.44U AS=0.2684P AD=0.2684P
+ PS=2.1U PD=2.1U
M$204 \$290 \$292 \$295 GND nfet_03v3 L=0.28U W=0.44U AS=0.2684P AD=0.2684P
+ PS=2.1U PD=2.1U
M$205 \$321 \$316 \$318 GND nfet_03v3 L=0.28U W=0.44U AS=0.2684P AD=0.2684P
+ PS=2.1U PD=2.1U
M$206 \$92 ONEHOT_25 GND GND nfet_03v3 L=0.28U W=0.44U AS=0.2684P AD=0.2684P
+ PS=2.1U PD=2.1U
M$207 GND ONEHOT_25 \$71 GND nfet_03v3 L=0.28U W=0.44U AS=0.2684P AD=0.2684P
+ PS=2.1U PD=2.1U
M$208 \$335 \$334 \$331 GND nfet_03v3 L=0.28U W=0.44U AS=0.2684P AD=0.2684P
+ PS=2.1U PD=2.1U
M$209 \$339 \$336 \$338 GND nfet_03v3 L=0.28U W=0.44U AS=0.2684P AD=0.2684P
+ PS=2.1U PD=2.1U
M$210 \$36 ONEHOT_25 GND GND nfet_03v3 L=0.28U W=0.44U AS=0.2684P AD=0.2684P
+ PS=2.1U PD=2.1U
M$211 GND ONEHOT_57 \$93 GND nfet_03v3 L=0.28U W=0.44U AS=0.2684P AD=0.2684P
+ PS=2.1U PD=2.1U
M$212 \$94 ONEHOT_57 GND GND nfet_03v3 L=0.28U W=0.44U AS=0.2684P AD=0.2684P
+ PS=2.1U PD=2.1U
M$213 \$330 \$332 \$333 GND nfet_03v3 L=0.28U W=0.44U AS=0.2684P AD=0.2684P
+ PS=2.1U PD=2.1U
M$214 \$324 \$325 \$328 GND nfet_03v3 L=0.28U W=0.44U AS=0.2684P AD=0.2684P
+ PS=2.1U PD=2.1U
M$215 GND ONEHOT_57 \$37 GND nfet_03v3 L=0.28U W=0.44U AS=0.2684P AD=0.2684P
+ PS=2.1U PD=2.1U
M$216 \$317 \$319 \$320 GND nfet_03v3 L=0.28U W=0.44U AS=0.2684P AD=0.2684P
+ PS=2.1U PD=2.1U
M$217 \$348 \$343 \$345 GND nfet_03v3 L=0.28U W=0.44U AS=0.2684P AD=0.2684P
+ PS=2.1U PD=2.1U
M$218 \$92 ONEHOT_24 GND GND nfet_03v3 L=0.28U W=0.44U AS=0.2684P AD=0.2684P
+ PS=2.1U PD=2.1U
M$219 GND ONEHOT_24 \$71 GND nfet_03v3 L=0.28U W=0.44U AS=0.2684P AD=0.2684P
+ PS=2.1U PD=2.1U
M$220 \$366 \$365 \$363 GND nfet_03v3 L=0.28U W=0.44U AS=0.2684P AD=0.2684P
+ PS=2.1U PD=2.1U
M$221 \$371 \$368 \$369 GND nfet_03v3 L=0.28U W=0.44U AS=0.2684P AD=0.2684P
+ PS=2.1U PD=2.1U
M$222 \$375 \$374 \$373 GND nfet_03v3 L=0.28U W=0.44U AS=0.2684P AD=0.2684P
+ PS=2.1U PD=2.1U
M$223 GND ONEHOT_56 \$93 GND nfet_03v3 L=0.28U W=0.44U AS=0.2684P AD=0.2684P
+ PS=2.1U PD=2.1U
M$224 \$94 ONEHOT_56 GND GND nfet_03v3 L=0.28U W=0.44U AS=0.2684P AD=0.2684P
+ PS=2.1U PD=2.1U
M$225 \$360 \$361 \$364 GND nfet_03v3 L=0.28U W=0.44U AS=0.2684P AD=0.2684P
+ PS=2.1U PD=2.1U
M$226 \$355 \$356 \$358 GND nfet_03v3 L=0.28U W=0.44U AS=0.2684P AD=0.2684P
+ PS=2.1U PD=2.1U
M$227 \$350 \$354 \$353 GND nfet_03v3 L=0.28U W=0.44U AS=0.2684P AD=0.2684P
+ PS=2.1U PD=2.1U
M$228 \$344 \$346 \$347 GND nfet_03v3 L=0.28U W=0.44U AS=0.2684P AD=0.2684P
+ PS=2.1U PD=2.1U
M$229 \$383 \$378 \$379 GND nfet_03v3 L=0.28U W=0.44U AS=0.2684P AD=0.2684P
+ PS=2.1U PD=2.1U
M$230 \$92 ONEHOT_23 GND GND nfet_03v3 L=0.28U W=0.44U AS=0.2684P AD=0.2684P
+ PS=2.1U PD=2.1U
M$231 \$389 \$386 \$387 GND nfet_03v3 L=0.28U W=0.44U AS=0.2684P AD=0.2684P
+ PS=2.1U PD=2.1U
M$232 \$72 ONEHOT_23 GND GND nfet_03v3 L=0.28U W=0.44U AS=0.2684P AD=0.2684P
+ PS=2.1U PD=2.1U
M$233 GND ONEHOT_23 \$35 GND nfet_03v3 L=0.28U W=0.44U AS=0.2684P AD=0.2684P
+ PS=2.1U PD=2.1U
M$234 \$36 ONEHOT_23 GND GND nfet_03v3 L=0.28U W=0.44U AS=0.2684P AD=0.2684P
+ PS=2.1U PD=2.1U
M$235 GND ONEHOT_55 \$93 GND nfet_03v3 L=0.28U W=0.44U AS=0.2684P AD=0.2684P
+ PS=2.1U PD=2.1U
M$236 \$391 \$392 \$393 GND nfet_03v3 L=0.28U W=0.44U AS=0.2684P AD=0.2684P
+ PS=2.1U PD=2.1U
M$237 GND ONEHOT_55 \$73 GND nfet_03v3 L=0.28U W=0.44U AS=0.2684P AD=0.2684P
+ PS=2.1U PD=2.1U
M$238 \$74 ONEHOT_55 GND GND nfet_03v3 L=0.28U W=0.44U AS=0.2684P AD=0.2684P
+ PS=2.1U PD=2.1U
M$239 GND ONEHOT_55 \$37 GND nfet_03v3 L=0.28U W=0.44U AS=0.2684P AD=0.2684P
+ PS=2.1U PD=2.1U
M$240 \$380 \$381 \$382 GND nfet_03v3 L=0.28U W=0.44U AS=0.2684P AD=0.2684P
+ PS=2.1U PD=2.1U
M$241 \$402 \$398 \$400 GND nfet_03v3 L=0.28U W=0.44U AS=0.2684P AD=0.2684P
+ PS=2.1U PD=2.1U
M$242 \$92 ONEHOT_22 GND GND nfet_03v3 L=0.28U W=0.44U AS=0.2684P AD=0.2684P
+ PS=2.1U PD=2.1U
M$243 \$413 \$410 \$411 GND nfet_03v3 L=0.28U W=0.44U AS=0.2684P AD=0.2684P
+ PS=2.1U PD=2.1U
M$244 \$72 ONEHOT_22 GND GND nfet_03v3 L=0.28U W=0.44U AS=0.2684P AD=0.2684P
+ PS=2.1U PD=2.1U
M$245 GND ONEHOT_22 \$35 GND nfet_03v3 L=0.28U W=0.44U AS=0.2684P AD=0.2684P
+ PS=2.1U PD=2.1U
M$246 \$422 \$421 \$420 GND nfet_03v3 L=0.28U W=0.44U AS=0.2684P AD=0.2684P
+ PS=2.1U PD=2.1U
M$247 GND ONEHOT_54 \$93 GND nfet_03v3 L=0.28U W=0.44U AS=0.2684P AD=0.2684P
+ PS=2.1U PD=2.1U
M$248 \$415 \$416 \$417 GND nfet_03v3 L=0.28U W=0.44U AS=0.2684P AD=0.2684P
+ PS=2.1U PD=2.1U
M$249 GND ONEHOT_54 \$73 GND nfet_03v3 L=0.28U W=0.44U AS=0.2684P AD=0.2684P
+ PS=2.1U PD=2.1U
M$250 \$74 ONEHOT_54 GND GND nfet_03v3 L=0.28U W=0.44U AS=0.2684P AD=0.2684P
+ PS=2.1U PD=2.1U
M$251 \$406 \$407 \$408 GND nfet_03v3 L=0.28U W=0.44U AS=0.2684P AD=0.2684P
+ PS=2.1U PD=2.1U
M$252 \$399 \$401 \$405 GND nfet_03v3 L=0.28U W=0.44U AS=0.2684P AD=0.2684P
+ PS=2.1U PD=2.1U
M$253 \$430 \$425 \$426 GND nfet_03v3 L=0.28U W=0.44U AS=0.2684P AD=0.2684P
+ PS=2.1U PD=2.1U
M$254 \$92 ONEHOT_21 GND GND nfet_03v3 L=0.28U W=0.44U AS=0.2684P AD=0.2684P
+ PS=2.1U PD=2.1U
M$255 \$437 \$433 \$434 GND nfet_03v3 L=0.28U W=0.44U AS=0.2684P AD=0.2684P
+ PS=2.1U PD=2.1U
M$256 \$72 ONEHOT_21 GND GND nfet_03v3 L=0.28U W=0.44U AS=0.2684P AD=0.2684P
+ PS=2.1U PD=2.1U
M$257 \$445 \$441 \$442 GND nfet_03v3 L=0.28U W=0.44U AS=0.2684P AD=0.2684P
+ PS=2.1U PD=2.1U
M$258 \$36 ONEHOT_21 GND GND nfet_03v3 L=0.28U W=0.44U AS=0.2684P AD=0.2684P
+ PS=2.1U PD=2.1U
M$259 GND ONEHOT_53 \$93 GND nfet_03v3 L=0.28U W=0.44U AS=0.2684P AD=0.2684P
+ PS=2.1U PD=2.1U
M$260 \$443 \$444 \$446 GND nfet_03v3 L=0.28U W=0.44U AS=0.2684P AD=0.2684P
+ PS=2.1U PD=2.1U
M$261 GND ONEHOT_53 \$73 GND nfet_03v3 L=0.28U W=0.44U AS=0.2684P AD=0.2684P
+ PS=2.1U PD=2.1U
M$262 \$435 \$436 \$439 GND nfet_03v3 L=0.28U W=0.44U AS=0.2684P AD=0.2684P
+ PS=2.1U PD=2.1U
M$263 GND ONEHOT_53 \$37 GND nfet_03v3 L=0.28U W=0.44U AS=0.2684P AD=0.2684P
+ PS=2.1U PD=2.1U
M$264 \$427 \$428 \$431 GND nfet_03v3 L=0.28U W=0.44U AS=0.2684P AD=0.2684P
+ PS=2.1U PD=2.1U
M$265 \$455 \$451 \$452 GND nfet_03v3 L=0.28U W=0.44U AS=0.2684P AD=0.2684P
+ PS=2.1U PD=2.1U
M$266 \$92 ONEHOT_20 GND GND nfet_03v3 L=0.28U W=0.44U AS=0.2684P AD=0.2684P
+ PS=2.1U PD=2.1U
M$267 \$469 \$464 \$467 GND nfet_03v3 L=0.28U W=0.44U AS=0.2684P AD=0.2684P
+ PS=2.1U PD=2.1U
M$268 \$72 ONEHOT_20 GND GND nfet_03v3 L=0.28U W=0.44U AS=0.2684P AD=0.2684P
+ PS=2.1U PD=2.1U
M$269 \$477 \$471 \$474 GND nfet_03v3 L=0.28U W=0.44U AS=0.2684P AD=0.2684P
+ PS=2.1U PD=2.1U
M$270 \$482 \$481 \$480 GND nfet_03v3 L=0.28U W=0.44U AS=0.2684P AD=0.2684P
+ PS=2.1U PD=2.1U
M$271 GND ONEHOT_52 \$93 GND nfet_03v3 L=0.28U W=0.44U AS=0.2684P AD=0.2684P
+ PS=2.1U PD=2.1U
M$272 \$472 \$473 \$475 GND nfet_03v3 L=0.28U W=0.44U AS=0.2684P AD=0.2684P
+ PS=2.1U PD=2.1U
M$273 GND ONEHOT_52 \$73 GND nfet_03v3 L=0.28U W=0.44U AS=0.2684P AD=0.2684P
+ PS=2.1U PD=2.1U
M$274 \$463 \$465 \$466 GND nfet_03v3 L=0.28U W=0.44U AS=0.2684P AD=0.2684P
+ PS=2.1U PD=2.1U
M$275 \$459 \$462 \$460 GND nfet_03v3 L=0.28U W=0.44U AS=0.2684P AD=0.2684P
+ PS=2.1U PD=2.1U
M$276 \$453 \$454 \$456 GND nfet_03v3 L=0.28U W=0.44U AS=0.2684P AD=0.2684P
+ PS=2.1U PD=2.1U
M$277 \$489 \$485 \$487 GND nfet_03v3 L=0.28U W=0.44U AS=0.2684P AD=0.2684P
+ PS=2.1U PD=2.1U
M$278 \$92 ONEHOT_19 GND GND nfet_03v3 L=0.28U W=0.44U AS=0.2684P AD=0.2684P
+ PS=2.1U PD=2.1U
M$279 \$496 \$493 \$494 GND nfet_03v3 L=0.28U W=0.44U AS=0.2684P AD=0.2684P
+ PS=2.1U PD=2.1U
M$280 \$502 \$501 \$499 GND nfet_03v3 L=0.28U W=0.44U AS=0.2684P AD=0.2684P
+ PS=2.1U PD=2.1U
M$281 GND ONEHOT_19 \$35 GND nfet_03v3 L=0.28U W=0.44U AS=0.2684P AD=0.2684P
+ PS=2.1U PD=2.1U
M$282 \$36 ONEHOT_19 GND GND nfet_03v3 L=0.28U W=0.44U AS=0.2684P AD=0.2684P
+ PS=2.1U PD=2.1U
M$283 GND ONEHOT_51 \$93 GND nfet_03v3 L=0.28U W=0.44U AS=0.2684P AD=0.2684P
+ PS=2.1U PD=2.1U
M$284 \$505 \$506 \$507 GND nfet_03v3 L=0.28U W=0.44U AS=0.2684P AD=0.2684P
+ PS=2.1U PD=2.1U
M$285 \$500 \$504 \$503 GND nfet_03v3 L=0.28U W=0.44U AS=0.2684P AD=0.2684P
+ PS=2.1U PD=2.1U
M$286 \$74 ONEHOT_51 GND GND nfet_03v3 L=0.28U W=0.44U AS=0.2684P AD=0.2684P
+ PS=2.1U PD=2.1U
M$287 GND ONEHOT_51 \$37 GND nfet_03v3 L=0.28U W=0.44U AS=0.2684P AD=0.2684P
+ PS=2.1U PD=2.1U
M$288 \$486 \$488 \$491 GND nfet_03v3 L=0.28U W=0.44U AS=0.2684P AD=0.2684P
+ PS=2.1U PD=2.1U
M$289 \$516 \$512 \$513 GND nfet_03v3 L=0.28U W=0.44U AS=0.2684P AD=0.2684P
+ PS=2.1U PD=2.1U
M$290 \$92 ONEHOT_18 GND GND nfet_03v3 L=0.28U W=0.44U AS=0.2684P AD=0.2684P
+ PS=2.1U PD=2.1U
M$291 \$527 \$524 \$525 GND nfet_03v3 L=0.28U W=0.44U AS=0.2684P AD=0.2684P
+ PS=2.1U PD=2.1U
M$292 \$534 \$533 \$531 GND nfet_03v3 L=0.28U W=0.44U AS=0.2684P AD=0.2684P
+ PS=2.1U PD=2.1U
M$293 GND ONEHOT_18 \$35 GND nfet_03v3 L=0.28U W=0.44U AS=0.2684P AD=0.2684P
+ PS=2.1U PD=2.1U
M$294 \$543 \$542 \$541 GND nfet_03v3 L=0.28U W=0.44U AS=0.2684P AD=0.2684P
+ PS=2.1U PD=2.1U
M$295 GND ONEHOT_50 \$93 GND nfet_03v3 L=0.28U W=0.44U AS=0.2684P AD=0.2684P
+ PS=2.1U PD=2.1U
M$296 \$536 \$537 \$538 GND nfet_03v3 L=0.28U W=0.44U AS=0.2684P AD=0.2684P
+ PS=2.1U PD=2.1U
M$297 \$529 \$535 \$532 GND nfet_03v3 L=0.28U W=0.44U AS=0.2684P AD=0.2684P
+ PS=2.1U PD=2.1U
M$298 \$74 ONEHOT_50 GND GND nfet_03v3 L=0.28U W=0.44U AS=0.2684P AD=0.2684P
+ PS=2.1U PD=2.1U
M$299 \$519 \$523 \$522 GND nfet_03v3 L=0.28U W=0.44U AS=0.2684P AD=0.2684P
+ PS=2.1U PD=2.1U
M$300 \$514 \$515 \$517 GND nfet_03v3 L=0.28U W=0.44U AS=0.2684P AD=0.2684P
+ PS=2.1U PD=2.1U
M$301 \$551 \$546 \$547 GND nfet_03v3 L=0.28U W=0.44U AS=0.2684P AD=0.2684P
+ PS=2.1U PD=2.1U
M$302 \$92 ONEHOT_17 GND GND nfet_03v3 L=0.28U W=0.44U AS=0.2684P AD=0.2684P
+ PS=2.1U PD=2.1U
M$303 \$559 \$554 \$555 GND nfet_03v3 L=0.28U W=0.44U AS=0.2684P AD=0.2684P
+ PS=2.1U PD=2.1U
M$304 \$568 \$566 \$564 GND nfet_03v3 L=0.28U W=0.44U AS=0.2684P AD=0.2684P
+ PS=2.1U PD=2.1U
M$305 \$575 \$570 \$572 GND nfet_03v3 L=0.28U W=0.44U AS=0.2684P AD=0.2684P
+ PS=2.1U PD=2.1U
M$306 \$36 ONEHOT_17 GND GND nfet_03v3 L=0.28U W=0.44U AS=0.2684P AD=0.2684P
+ PS=2.1U PD=2.1U
M$307 GND ONEHOT_49 \$93 GND nfet_03v3 L=0.28U W=0.44U AS=0.2684P AD=0.2684P
+ PS=2.1U PD=2.1U
M$308 \$571 \$573 \$574 GND nfet_03v3 L=0.28U W=0.44U AS=0.2684P AD=0.2684P
+ PS=2.1U PD=2.1U
M$309 \$565 \$569 \$567 GND nfet_03v3 L=0.28U W=0.44U AS=0.2684P AD=0.2684P
+ PS=2.1U PD=2.1U
M$310 \$556 \$557 \$560 GND nfet_03v3 L=0.28U W=0.44U AS=0.2684P AD=0.2684P
+ PS=2.1U PD=2.1U
M$311 GND ONEHOT_49 \$37 GND nfet_03v3 L=0.28U W=0.44U AS=0.2684P AD=0.2684P
+ PS=2.1U PD=2.1U
M$312 \$548 \$549 \$550 GND nfet_03v3 L=0.28U W=0.44U AS=0.2684P AD=0.2684P
+ PS=2.1U PD=2.1U
M$313 \$585 \$580 \$581 GND nfet_03v3 L=0.28U W=0.44U AS=0.2684P AD=0.2684P
+ PS=2.1U PD=2.1U
M$314 \$92 ONEHOT_16 GND GND nfet_03v3 L=0.28U W=0.44U AS=0.2684P AD=0.2684P
+ PS=2.1U PD=2.1U
M$315 \$599 \$593 \$595 GND nfet_03v3 L=0.28U W=0.44U AS=0.2684P AD=0.2684P
+ PS=2.1U PD=2.1U
M$316 \$610 \$604 \$605 GND nfet_03v3 L=0.28U W=0.44U AS=0.2684P AD=0.2684P
+ PS=2.1U PD=2.1U
M$317 \$614 \$612 \$613 GND nfet_03v3 L=0.28U W=0.44U AS=0.2684P AD=0.2684P
+ PS=2.1U PD=2.1U
M$318 \$616 \$617 \$619 GND nfet_03v3 L=0.28U W=0.44U AS=0.2684P AD=0.2684P
+ PS=2.1U PD=2.1U
M$319 GND ONEHOT_48 \$93 GND nfet_03v3 L=0.28U W=0.44U AS=0.2684P AD=0.2684P
+ PS=2.1U PD=2.1U
M$320 \$606 \$611 \$609 GND nfet_03v3 L=0.28U W=0.44U AS=0.2684P AD=0.2684P
+ PS=2.1U PD=2.1U
M$321 \$600 \$603 \$601 GND nfet_03v3 L=0.28U W=0.44U AS=0.2684P AD=0.2684P
+ PS=2.1U PD=2.1U
M$322 \$592 \$597 \$596 GND nfet_03v3 L=0.28U W=0.44U AS=0.2684P AD=0.2684P
+ PS=2.1U PD=2.1U
M$323 \$588 \$591 \$589 GND nfet_03v3 L=0.28U W=0.44U AS=0.2684P AD=0.2684P
+ PS=2.1U PD=2.1U
M$324 \$582 \$583 \$584 GND nfet_03v3 L=0.28U W=0.44U AS=0.2684P AD=0.2684P
+ PS=2.1U PD=2.1U
M$325 \$630 \$625 \$626 GND nfet_03v3 L=0.28U W=0.44U AS=0.2684P AD=0.2684P
+ PS=2.1U PD=2.1U
M$326 \$638 \$637 \$635 GND nfet_03v3 L=0.28U W=0.44U AS=0.2684P AD=0.2684P
+ PS=2.1U PD=2.1U
M$327 GND ONEHOT_15 \$71 GND nfet_03v3 L=0.28U W=0.44U AS=0.2684P AD=0.2684P
+ PS=2.1U PD=2.1U
M$328 \$72 ONEHOT_15 GND GND nfet_03v3 L=0.28U W=0.44U AS=0.2684P AD=0.2684P
+ PS=2.1U PD=2.1U
M$329 GND ONEHOT_15 \$35 GND nfet_03v3 L=0.28U W=0.44U AS=0.2684P AD=0.2684P
+ PS=2.1U PD=2.1U
M$330 \$36 ONEHOT_15 GND GND nfet_03v3 L=0.28U W=0.44U AS=0.2684P AD=0.2684P
+ PS=2.1U PD=2.1U
M$331 \$657 \$660 \$655 GND nfet_03v3 L=0.28U W=0.44U AS=0.2684P AD=0.2684P
+ PS=2.1U PD=2.1U
M$332 \$94 ONEHOT_47 GND GND nfet_03v3 L=0.28U W=0.44U AS=0.2684P AD=0.2684P
+ PS=2.1U PD=2.1U
M$333 GND ONEHOT_47 \$73 GND nfet_03v3 L=0.28U W=0.44U AS=0.2684P AD=0.2684P
+ PS=2.1U PD=2.1U
M$334 \$74 ONEHOT_47 GND GND nfet_03v3 L=0.28U W=0.44U AS=0.2684P AD=0.2684P
+ PS=2.1U PD=2.1U
M$335 GND ONEHOT_47 \$37 GND nfet_03v3 L=0.28U W=0.44U AS=0.2684P AD=0.2684P
+ PS=2.1U PD=2.1U
M$336 \$640 \$644 \$652 GND nfet_03v3 L=0.28U W=0.44U AS=0.2684P AD=0.2684P
+ PS=2.1U PD=2.1U
M$337 \$631 \$624 \$627 GND nfet_03v3 L=0.28U W=0.44U AS=0.2684P AD=0.2684P
+ PS=2.1U PD=2.1U
M$338 \$639 \$636 \$634 GND nfet_03v3 L=0.28U W=0.44U AS=0.2684P AD=0.2684P
+ PS=2.1U PD=2.1U
M$339 GND ONEHOT_14 \$71 GND nfet_03v3 L=0.28U W=0.44U AS=0.2684P AD=0.2684P
+ PS=2.1U PD=2.1U
M$340 \$72 ONEHOT_14 GND GND nfet_03v3 L=0.28U W=0.44U AS=0.2684P AD=0.2684P
+ PS=2.1U PD=2.1U
M$341 GND ONEHOT_14 \$35 GND nfet_03v3 L=0.28U W=0.44U AS=0.2684P AD=0.2684P
+ PS=2.1U PD=2.1U
M$342 \$654 \$653 \$650 GND nfet_03v3 L=0.28U W=0.44U AS=0.2684P AD=0.2684P
+ PS=2.1U PD=2.1U
M$343 \$658 \$659 \$656 GND nfet_03v3 L=0.28U W=0.44U AS=0.2684P AD=0.2684P
+ PS=2.1U PD=2.1U
M$344 \$94 ONEHOT_46 GND GND nfet_03v3 L=0.28U W=0.44U AS=0.2684P AD=0.2684P
+ PS=2.1U PD=2.1U
M$345 GND ONEHOT_46 \$73 GND nfet_03v3 L=0.28U W=0.44U AS=0.2684P AD=0.2684P
+ PS=2.1U PD=2.1U
M$346 \$74 ONEHOT_46 GND GND nfet_03v3 L=0.28U W=0.44U AS=0.2684P AD=0.2684P
+ PS=2.1U PD=2.1U
M$347 \$664 \$667 \$668 GND nfet_03v3 L=0.28U W=0.44U AS=0.2684P AD=0.2684P
+ PS=2.1U PD=2.1U
M$348 \$641 \$645 \$648 GND nfet_03v3 L=0.28U W=0.44U AS=0.2684P AD=0.2684P
+ PS=2.1U PD=2.1U
M$349 \$673 \$672 \$671 GND nfet_03v3 L=0.28U W=0.44U AS=0.2684P AD=0.2684P
+ PS=2.1U PD=2.1U
M$350 \$682 \$680 \$676 GND nfet_03v3 L=0.28U W=0.44U AS=0.2684P AD=0.2684P
+ PS=2.1U PD=2.1U
M$351 GND ONEHOT_13 \$71 GND nfet_03v3 L=0.28U W=0.44U AS=0.2684P AD=0.2684P
+ PS=2.1U PD=2.1U
M$352 \$72 ONEHOT_13 GND GND nfet_03v3 L=0.28U W=0.44U AS=0.2684P AD=0.2684P
+ PS=2.1U PD=2.1U
M$353 \$686 \$685 \$684 GND nfet_03v3 L=0.28U W=0.44U AS=0.2684P AD=0.2684P
+ PS=2.1U PD=2.1U
M$354 \$36 ONEHOT_13 GND GND nfet_03v3 L=0.28U W=0.44U AS=0.2684P AD=0.2684P
+ PS=2.1U PD=2.1U
M$355 \$691 \$692 \$690 GND nfet_03v3 L=0.28U W=0.44U AS=0.2684P AD=0.2684P
+ PS=2.1U PD=2.1U
M$356 \$94 ONEHOT_45 GND GND nfet_03v3 L=0.28U W=0.44U AS=0.2684P AD=0.2684P
+ PS=2.1U PD=2.1U
M$357 GND ONEHOT_45 \$73 GND nfet_03v3 L=0.28U W=0.44U AS=0.2684P AD=0.2684P
+ PS=2.1U PD=2.1U
M$358 \$688 \$689 \$693 GND nfet_03v3 L=0.28U W=0.44U AS=0.2684P AD=0.2684P
+ PS=2.1U PD=2.1U
M$359 GND ONEHOT_45 \$37 GND nfet_03v3 L=0.28U W=0.44U AS=0.2684P AD=0.2684P
+ PS=2.1U PD=2.1U
M$360 \$674 \$675 \$681 GND nfet_03v3 L=0.28U W=0.44U AS=0.2684P AD=0.2684P
+ PS=2.1U PD=2.1U
M$361 \$703 \$698 \$699 GND nfet_03v3 L=0.28U W=0.44U AS=0.2684P AD=0.2684P
+ PS=2.1U PD=2.1U
M$362 \$712 \$711 \$708 GND nfet_03v3 L=0.28U W=0.44U AS=0.2684P AD=0.2684P
+ PS=2.1U PD=2.1U
M$363 GND ONEHOT_12 \$71 GND nfet_03v3 L=0.28U W=0.44U AS=0.2684P AD=0.2684P
+ PS=2.1U PD=2.1U
M$364 \$72 ONEHOT_12 GND GND nfet_03v3 L=0.28U W=0.44U AS=0.2684P AD=0.2684P
+ PS=2.1U PD=2.1U
M$365 \$722 \$721 \$719 GND nfet_03v3 L=0.28U W=0.44U AS=0.2684P AD=0.2684P
+ PS=2.1U PD=2.1U
M$366 \$729 \$727 \$723 GND nfet_03v3 L=0.28U W=0.44U AS=0.2684P AD=0.2684P
+ PS=2.1U PD=2.1U
M$367 \$728 \$726 \$730 GND nfet_03v3 L=0.28U W=0.44U AS=0.2684P AD=0.2684P
+ PS=2.1U PD=2.1U
M$368 \$94 ONEHOT_44 GND GND nfet_03v3 L=0.28U W=0.44U AS=0.2684P AD=0.2684P
+ PS=2.1U PD=2.1U
M$369 GND ONEHOT_44 \$73 GND nfet_03v3 L=0.28U W=0.44U AS=0.2684P AD=0.2684P
+ PS=2.1U PD=2.1U
M$370 \$714 \$715 \$716 GND nfet_03v3 L=0.28U W=0.44U AS=0.2684P AD=0.2684P
+ PS=2.1U PD=2.1U
M$371 \$709 \$713 \$710 GND nfet_03v3 L=0.28U W=0.44U AS=0.2684P AD=0.2684P
+ PS=2.1U PD=2.1U
M$372 \$700 \$701 \$704 GND nfet_03v3 L=0.28U W=0.44U AS=0.2684P AD=0.2684P
+ PS=2.1U PD=2.1U
M$373 \$738 \$733 \$735 GND nfet_03v3 L=0.28U W=0.44U AS=0.2684P AD=0.2684P
+ PS=2.1U PD=2.1U
M$374 \$744 \$743 \$742 GND nfet_03v3 L=0.28U W=0.44U AS=0.2684P AD=0.2684P
+ PS=2.1U PD=2.1U
M$375 GND ONEHOT_11 \$71 GND nfet_03v3 L=0.28U W=0.44U AS=0.2684P AD=0.2684P
+ PS=2.1U PD=2.1U
M$376 \$749 \$748 \$746 GND nfet_03v3 L=0.28U W=0.44U AS=0.2684P AD=0.2684P
+ PS=2.1U PD=2.1U
M$377 GND ONEHOT_11 \$35 GND nfet_03v3 L=0.28U W=0.44U AS=0.2684P AD=0.2684P
+ PS=2.1U PD=2.1U
M$378 \$36 ONEHOT_11 GND GND nfet_03v3 L=0.28U W=0.44U AS=0.2684P AD=0.2684P
+ PS=2.1U PD=2.1U
M$379 \$755 \$757 \$756 GND nfet_03v3 L=0.28U W=0.44U AS=0.2684P AD=0.2684P
+ PS=2.1U PD=2.1U
M$380 \$94 ONEHOT_43 GND GND nfet_03v3 L=0.28U W=0.44U AS=0.2684P AD=0.2684P
+ PS=2.1U PD=2.1U
M$381 \$750 \$752 \$751 GND nfet_03v3 L=0.28U W=0.44U AS=0.2684P AD=0.2684P
+ PS=2.1U PD=2.1U
M$382 \$74 ONEHOT_43 GND GND nfet_03v3 L=0.28U W=0.44U AS=0.2684P AD=0.2684P
+ PS=2.1U PD=2.1U
M$383 GND ONEHOT_43 \$37 GND nfet_03v3 L=0.28U W=0.44U AS=0.2684P AD=0.2684P
+ PS=2.1U PD=2.1U
M$384 \$734 \$736 \$737 GND nfet_03v3 L=0.28U W=0.44U AS=0.2684P AD=0.2684P
+ PS=2.1U PD=2.1U
M$385 \$765 \$760 \$761 GND nfet_03v3 L=0.28U W=0.44U AS=0.2684P AD=0.2684P
+ PS=2.1U PD=2.1U
M$386 \$775 \$774 \$772 GND nfet_03v3 L=0.28U W=0.44U AS=0.2684P AD=0.2684P
+ PS=2.1U PD=2.1U
M$387 GND ONEHOT_10 \$71 GND nfet_03v3 L=0.28U W=0.44U AS=0.2684P AD=0.2684P
+ PS=2.1U PD=2.1U
M$388 \$782 \$781 \$778 GND nfet_03v3 L=0.28U W=0.44U AS=0.2684P AD=0.2684P
+ PS=2.1U PD=2.1U
M$389 GND ONEHOT_10 \$35 GND nfet_03v3 L=0.28U W=0.44U AS=0.2684P AD=0.2684P
+ PS=2.1U PD=2.1U
M$390 \$790 \$789 \$785 GND nfet_03v3 L=0.28U W=0.44U AS=0.2684P AD=0.2684P
+ PS=2.1U PD=2.1U
M$391 \$788 \$787 \$791 GND nfet_03v3 L=0.28U W=0.44U AS=0.2684P AD=0.2684P
+ PS=2.1U PD=2.1U
M$392 \$94 ONEHOT_42 GND GND nfet_03v3 L=0.28U W=0.44U AS=0.2684P AD=0.2684P
+ PS=2.1U PD=2.1U
M$393 \$777 \$780 \$783 GND nfet_03v3 L=0.28U W=0.44U AS=0.2684P AD=0.2684P
+ PS=2.1U PD=2.1U
M$394 \$74 ONEHOT_42 GND GND nfet_03v3 L=0.28U W=0.44U AS=0.2684P AD=0.2684P
+ PS=2.1U PD=2.1U
M$395 \$770 \$771 \$773 GND nfet_03v3 L=0.28U W=0.44U AS=0.2684P AD=0.2684P
+ PS=2.1U PD=2.1U
M$396 \$762 \$763 \$768 GND nfet_03v3 L=0.28U W=0.44U AS=0.2684P AD=0.2684P
+ PS=2.1U PD=2.1U
M$397 \$799 \$794 \$795 GND nfet_03v3 L=0.28U W=0.44U AS=0.2684P AD=0.2684P
+ PS=2.1U PD=2.1U
M$398 \$805 \$804 \$803 GND nfet_03v3 L=0.28U W=0.44U AS=0.2684P AD=0.2684P
+ PS=2.1U PD=2.1U
M$399 GND ONEHOT_9 \$71 GND nfet_03v3 L=0.28U W=0.44U AS=0.2684P AD=0.2684P
+ PS=2.1U PD=2.1U
M$400 \$817 \$816 \$813 GND nfet_03v3 L=0.28U W=0.44U AS=0.2684P AD=0.2684P
+ PS=2.1U PD=2.1U
M$401 \$821 \$818 \$820 GND nfet_03v3 L=0.28U W=0.44U AS=0.2684P AD=0.2684P
+ PS=2.1U PD=2.1U
M$402 \$36 ONEHOT_9 GND GND nfet_03v3 L=0.28U W=0.44U AS=0.2684P AD=0.2684P
+ PS=2.1U PD=2.1U
M$403 \$822 \$823 \$825 GND nfet_03v3 L=0.28U W=0.44U AS=0.2684P AD=0.2684P
+ PS=2.1U PD=2.1U
M$404 \$94 ONEHOT_41 GND GND nfet_03v3 L=0.28U W=0.44U AS=0.2684P AD=0.2684P
+ PS=2.1U PD=2.1U
M$405 \$812 \$814 \$815 GND nfet_03v3 L=0.28U W=0.44U AS=0.2684P AD=0.2684P
+ PS=2.1U PD=2.1U
M$406 \$806 \$807 \$810 GND nfet_03v3 L=0.28U W=0.44U AS=0.2684P AD=0.2684P
+ PS=2.1U PD=2.1U
M$407 GND ONEHOT_41 \$37 GND nfet_03v3 L=0.28U W=0.44U AS=0.2684P AD=0.2684P
+ PS=2.1U PD=2.1U
M$408 \$796 \$797 \$800 GND nfet_03v3 L=0.28U W=0.44U AS=0.2684P AD=0.2684P
+ PS=2.1U PD=2.1U
M$409 \$832 \$828 \$829 GND nfet_03v3 L=0.28U W=0.44U AS=0.2684P AD=0.2684P
+ PS=2.1U PD=2.1U
M$410 \$842 \$840 \$838 GND nfet_03v3 L=0.28U W=0.44U AS=0.2684P AD=0.2684P
+ PS=2.1U PD=2.1U
M$411 GND ONEHOT_8 \$71 GND nfet_03v3 L=0.28U W=0.44U AS=0.2684P AD=0.2684P
+ PS=2.1U PD=2.1U
M$412 \$856 \$851 \$852 GND nfet_03v3 L=0.28U W=0.44U AS=0.2684P AD=0.2684P
+ PS=2.1U PD=2.1U
M$413 \$860 \$858 \$857 GND nfet_03v3 L=0.28U W=0.44U AS=0.2684P AD=0.2684P
+ PS=2.1U PD=2.1U
M$414 \$864 \$867 \$865 GND nfet_03v3 L=0.28U W=0.44U AS=0.2684P AD=0.2684P
+ PS=2.1U PD=2.1U
M$415 \$859 \$861 \$862 GND nfet_03v3 L=0.28U W=0.44U AS=0.2684P AD=0.2684P
+ PS=2.1U PD=2.1U
M$416 \$94 ONEHOT_40 GND GND nfet_03v3 L=0.28U W=0.44U AS=0.2684P AD=0.2684P
+ PS=2.1U PD=2.1U
M$417 \$849 \$853 \$850 GND nfet_03v3 L=0.28U W=0.44U AS=0.2684P AD=0.2684P
+ PS=2.1U PD=2.1U
M$418 \$844 \$847 \$846 GND nfet_03v3 L=0.28U W=0.44U AS=0.2684P AD=0.2684P
+ PS=2.1U PD=2.1U
M$419 \$839 \$843 \$841 GND nfet_03v3 L=0.28U W=0.44U AS=0.2684P AD=0.2684P
+ PS=2.1U PD=2.1U
M$420 \$830 \$835 \$833 GND nfet_03v3 L=0.28U W=0.44U AS=0.2684P AD=0.2684P
+ PS=2.1U PD=2.1U
M$421 \$877 \$873 \$872 GND nfet_03v3 L=0.28U W=0.44U AS=0.2684P AD=0.2684P
+ PS=2.1U PD=2.1U
M$422 \$886 \$884 \$879 GND nfet_03v3 L=0.28U W=0.44U AS=0.2684P AD=0.2684P
+ PS=2.1U PD=2.1U
M$423 \$894 \$889 \$890 GND nfet_03v3 L=0.28U W=0.44U AS=0.2684P AD=0.2684P
+ PS=2.1U PD=2.1U
M$424 \$72 ONEHOT_7 GND GND nfet_03v3 L=0.28U W=0.44U AS=0.2684P AD=0.2684P
+ PS=2.1U PD=2.1U
M$425 GND ONEHOT_7 \$35 GND nfet_03v3 L=0.28U W=0.44U AS=0.2684P AD=0.2684P
+ PS=2.1U PD=2.1U
M$426 \$36 ONEHOT_7 GND GND nfet_03v3 L=0.28U W=0.44U AS=0.2684P AD=0.2684P
+ PS=2.1U PD=2.1U
M$427 \$911 \$914 \$909 GND nfet_03v3 L=0.28U W=0.44U AS=0.2684P AD=0.2684P
+ PS=2.1U PD=2.1U
M$428 \$923 \$916 \$919 GND nfet_03v3 L=0.28U W=0.44U AS=0.2684P AD=0.2684P
+ PS=2.1U PD=2.1U
M$429 GND ONEHOT_39 \$73 GND nfet_03v3 L=0.28U W=0.44U AS=0.2684P AD=0.2684P
+ PS=2.1U PD=2.1U
M$430 \$74 ONEHOT_39 GND GND nfet_03v3 L=0.28U W=0.44U AS=0.2684P AD=0.2684P
+ PS=2.1U PD=2.1U
M$431 GND ONEHOT_39 \$37 GND nfet_03v3 L=0.28U W=0.44U AS=0.2684P AD=0.2684P
+ PS=2.1U PD=2.1U
M$432 \$895 \$899 \$906 GND nfet_03v3 L=0.28U W=0.44U AS=0.2684P AD=0.2684P
+ PS=2.1U PD=2.1U
M$433 \$876 \$875 \$874 GND nfet_03v3 L=0.28U W=0.44U AS=0.2684P AD=0.2684P
+ PS=2.1U PD=2.1U
M$434 \$887 \$885 \$878 GND nfet_03v3 L=0.28U W=0.44U AS=0.2684P AD=0.2684P
+ PS=2.1U PD=2.1U
M$435 \$893 \$888 \$891 GND nfet_03v3 L=0.28U W=0.44U AS=0.2684P AD=0.2684P
+ PS=2.1U PD=2.1U
M$436 \$72 ONEHOT_6 GND GND nfet_03v3 L=0.28U W=0.44U AS=0.2684P AD=0.2684P
+ PS=2.1U PD=2.1U
M$437 GND ONEHOT_6 \$35 GND nfet_03v3 L=0.28U W=0.44U AS=0.2684P AD=0.2684P
+ PS=2.1U PD=2.1U
M$438 \$908 \$907 \$904 GND nfet_03v3 L=0.28U W=0.44U AS=0.2684P AD=0.2684P
+ PS=2.1U PD=2.1U
M$439 \$912 \$913 \$910 GND nfet_03v3 L=0.28U W=0.44U AS=0.2684P AD=0.2684P
+ PS=2.1U PD=2.1U
M$440 \$924 \$915 \$920 GND nfet_03v3 L=0.28U W=0.44U AS=0.2684P AD=0.2684P
+ PS=2.1U PD=2.1U
M$441 GND ONEHOT_38 \$73 GND nfet_03v3 L=0.28U W=0.44U AS=0.2684P AD=0.2684P
+ PS=2.1U PD=2.1U
M$442 \$74 ONEHOT_38 GND GND nfet_03v3 L=0.28U W=0.44U AS=0.2684P AD=0.2684P
+ PS=2.1U PD=2.1U
M$443 \$928 \$930 \$929 GND nfet_03v3 L=0.28U W=0.44U AS=0.2684P AD=0.2684P
+ PS=2.1U PD=2.1U
M$444 \$892 \$898 \$902 GND nfet_03v3 L=0.28U W=0.44U AS=0.2684P AD=0.2684P
+ PS=2.1U PD=2.1U
M$445 \$937 \$933 \$934 GND nfet_03v3 L=0.28U W=0.44U AS=0.2684P AD=0.2684P
+ PS=2.1U PD=2.1U
M$446 \$944 \$943 \$941 GND nfet_03v3 L=0.28U W=0.44U AS=0.2684P AD=0.2684P
+ PS=2.1U PD=2.1U
M$447 \$947 \$945 \$946 GND nfet_03v3 L=0.28U W=0.44U AS=0.2684P AD=0.2684P
+ PS=2.1U PD=2.1U
M$448 \$72 ONEHOT_5 GND GND nfet_03v3 L=0.28U W=0.44U AS=0.2684P AD=0.2684P
+ PS=2.1U PD=2.1U
M$449 \$955 \$954 \$953 GND nfet_03v3 L=0.28U W=0.44U AS=0.2684P AD=0.2684P
+ PS=2.1U PD=2.1U
M$450 \$36 ONEHOT_5 GND GND nfet_03v3 L=0.28U W=0.44U AS=0.2684P AD=0.2684P
+ PS=2.1U PD=2.1U
M$451 \$963 \$957 \$960 GND nfet_03v3 L=0.28U W=0.44U AS=0.2684P AD=0.2684P
+ PS=2.1U PD=2.1U
M$452 \$958 \$959 \$962 GND nfet_03v3 L=0.28U W=0.44U AS=0.2684P AD=0.2684P
+ PS=2.1U PD=2.1U
M$453 GND ONEHOT_37 \$73 GND nfet_03v3 L=0.28U W=0.44U AS=0.2684P AD=0.2684P
+ PS=2.1U PD=2.1U
M$454 \$948 \$949 \$951 GND nfet_03v3 L=0.28U W=0.44U AS=0.2684P AD=0.2684P
+ PS=2.1U PD=2.1U
M$455 GND ONEHOT_37 \$37 GND nfet_03v3 L=0.28U W=0.44U AS=0.2684P AD=0.2684P
+ PS=2.1U PD=2.1U
M$456 \$935 \$936 \$938 GND nfet_03v3 L=0.28U W=0.44U AS=0.2684P AD=0.2684P
+ PS=2.1U PD=2.1U
M$457 \$972 \$967 \$968 GND nfet_03v3 L=0.28U W=0.44U AS=0.2684P AD=0.2684P
+ PS=2.1U PD=2.1U
M$458 \$980 \$978 \$976 GND nfet_03v3 L=0.28U W=0.44U AS=0.2684P AD=0.2684P
+ PS=2.1U PD=2.1U
M$459 \$986 \$981 \$983 GND nfet_03v3 L=0.28U W=0.44U AS=0.2684P AD=0.2684P
+ PS=2.1U PD=2.1U
M$460 \$72 ONEHOT_4 GND GND nfet_03v3 L=0.28U W=0.44U AS=0.2684P AD=0.2684P
+ PS=2.1U PD=2.1U
M$461 \$994 \$992 \$991 GND nfet_03v3 L=0.28U W=0.44U AS=0.2684P AD=0.2684P
+ PS=2.1U PD=2.1U
M$462 \$999 \$993 \$996 GND nfet_03v3 L=0.28U W=0.44U AS=0.2684P AD=0.2684P
+ PS=2.1U PD=2.1U
M$463 \$1006 \$1003 \$1005 GND nfet_03v3 L=0.28U W=0.44U AS=0.2684P AD=0.2684P
+ PS=2.1U PD=2.1U
M$464 \$997 \$1000 \$1001 GND nfet_03v3 L=0.28U W=0.44U AS=0.2684P AD=0.2684P
+ PS=2.1U PD=2.1U
M$465 GND ONEHOT_36 \$73 GND nfet_03v3 L=0.28U W=0.44U AS=0.2684P AD=0.2684P
+ PS=2.1U PD=2.1U
M$466 \$985 \$987 \$988 GND nfet_03v3 L=0.28U W=0.44U AS=0.2684P AD=0.2684P
+ PS=2.1U PD=2.1U
M$467 \$979 \$984 \$982 GND nfet_03v3 L=0.28U W=0.44U AS=0.2684P AD=0.2684P
+ PS=2.1U PD=2.1U
M$468 \$969 \$971 \$974 GND nfet_03v3 L=0.28U W=0.44U AS=0.2684P AD=0.2684P
+ PS=2.1U PD=2.1U
M$469 \$1013 \$1009 \$1010 GND nfet_03v3 L=0.28U W=0.44U AS=0.2684P AD=0.2684P
+ PS=2.1U PD=2.1U
M$470 \$1020 \$1019 \$1017 GND nfet_03v3 L=0.28U W=0.44U AS=0.2684P AD=0.2684P
+ PS=2.1U PD=2.1U
M$471 \$1024 \$1021 \$1022 GND nfet_03v3 L=0.28U W=0.44U AS=0.2684P AD=0.2684P
+ PS=2.1U PD=2.1U
M$472 \$1029 \$1027 \$1026 GND nfet_03v3 L=0.28U W=0.44U AS=0.2684P AD=0.2684P
+ PS=2.1U PD=2.1U
M$473 GND ONEHOT_3 \$35 GND nfet_03v3 L=0.28U W=0.44U AS=0.2684P AD=0.2684P
+ PS=2.1U PD=2.1U
M$474 \$36 ONEHOT_3 GND GND nfet_03v3 L=0.28U W=0.44U AS=0.2684P AD=0.2684P
+ PS=2.1U PD=2.1U
M$475 \$1039 \$1034 \$1036 GND nfet_03v3 L=0.28U W=0.44U AS=0.2684P AD=0.2684P
+ PS=2.1U PD=2.1U
M$476 \$1035 \$1037 \$1038 GND nfet_03v3 L=0.28U W=0.44U AS=0.2684P AD=0.2684P
+ PS=2.1U PD=2.1U
M$477 \$1030 \$1033 \$1031 GND nfet_03v3 L=0.28U W=0.44U AS=0.2684P AD=0.2684P
+ PS=2.1U PD=2.1U
M$478 \$74 ONEHOT_35 GND GND nfet_03v3 L=0.28U W=0.44U AS=0.2684P AD=0.2684P
+ PS=2.1U PD=2.1U
M$479 GND ONEHOT_35 \$37 GND nfet_03v3 L=0.28U W=0.44U AS=0.2684P AD=0.2684P
+ PS=2.1U PD=2.1U
M$480 \$1011 \$1014 \$1015 GND nfet_03v3 L=0.28U W=0.44U AS=0.2684P AD=0.2684P
+ PS=2.1U PD=2.1U
M$481 \$1048 \$1044 \$1045 GND nfet_03v3 L=0.28U W=0.44U AS=0.2684P AD=0.2684P
+ PS=2.1U PD=2.1U
M$482 \$1056 \$1055 \$1052 GND nfet_03v3 L=0.28U W=0.44U AS=0.2684P AD=0.2684P
+ PS=2.1U PD=2.1U
M$483 \$1062 \$1060 \$1061 GND nfet_03v3 L=0.28U W=0.44U AS=0.2684P AD=0.2684P
+ PS=2.1U PD=2.1U
M$484 \$1068 \$1067 \$1066 GND nfet_03v3 L=0.28U W=0.44U AS=0.2684P AD=0.2684P
+ PS=2.1U PD=2.1U
M$485 GND ONEHOT_2 \$35 GND nfet_03v3 L=0.28U W=0.44U AS=0.2684P AD=0.2684P
+ PS=2.1U PD=2.1U
M$486 \$1076 \$1075 \$1072 GND nfet_03v3 L=0.28U W=0.44U AS=0.2684P AD=0.2684P
+ PS=2.1U PD=2.1U
M$487 \$1083 \$1080 \$1081 GND nfet_03v3 L=0.28U W=0.44U AS=0.2684P AD=0.2684P
+ PS=2.1U PD=2.1U
M$488 \$1074 \$1077 \$1079 GND nfet_03v3 L=0.28U W=0.44U AS=0.2684P AD=0.2684P
+ PS=2.1U PD=2.1U
M$489 \$1069 \$1073 \$1070 GND nfet_03v3 L=0.28U W=0.44U AS=0.2684P AD=0.2684P
+ PS=2.1U PD=2.1U
M$490 \$74 ONEHOT_34 GND GND nfet_03v3 L=0.28U W=0.44U AS=0.2684P AD=0.2684P
+ PS=2.1U PD=2.1U
M$491 \$1054 \$1058 \$1059 GND nfet_03v3 L=0.28U W=0.44U AS=0.2684P AD=0.2684P
+ PS=2.1U PD=2.1U
M$492 \$1046 \$1057 \$1050 GND nfet_03v3 L=0.28U W=0.44U AS=0.2684P AD=0.2684P
+ PS=2.1U PD=2.1U
M$493 \$1101 \$1100 \$1098 GND nfet_03v3 L=0.28U W=0.44U AS=0.2684P AD=0.2684P
+ PS=2.1U PD=2.1U
M$494 \$1105 \$1104 \$1103 GND nfet_03v3 L=0.28U W=0.44U AS=0.2684P AD=0.2684P
+ PS=2.1U PD=2.1U
M$495 \$1109 \$1108 \$1106 GND nfet_03v3 L=0.28U W=0.44U AS=0.2684P AD=0.2684P
+ PS=2.1U PD=2.1U
M$496 \$1114 \$1113 \$1111 GND nfet_03v3 L=0.28U W=0.44U AS=0.2684P AD=0.2684P
+ PS=2.1U PD=2.1U
M$497 \$1118 \$1117 \$1115 GND nfet_03v3 L=0.28U W=0.44U AS=0.2684P AD=0.2684P
+ PS=2.1U PD=2.1U
M$498 \$36 ONEHOT_1 GND GND nfet_03v3 L=0.28U W=0.44U AS=0.2684P AD=0.2684P
+ PS=2.1U PD=2.1U
M$499 \$1121 \$1122 \$1120 GND nfet_03v3 L=0.28U W=0.44U AS=0.2684P AD=0.2684P
+ PS=2.1U PD=2.1U
M$500 \$1127 \$1126 \$1125 GND nfet_03v3 L=0.28U W=0.44U AS=0.2684P AD=0.2684P
+ PS=2.1U PD=2.1U
M$501 \$1129 \$1130 \$1128 GND nfet_03v3 L=0.28U W=0.44U AS=0.2684P AD=0.2684P
+ PS=2.1U PD=2.1U
M$502 \$1135 \$1134 \$1133 GND nfet_03v3 L=0.28U W=0.44U AS=0.2684P AD=0.2684P
+ PS=2.1U PD=2.1U
M$503 GND ONEHOT_33 \$37 GND nfet_03v3 L=0.28U W=0.44U AS=0.2684P AD=0.2684P
+ PS=2.1U PD=2.1U
M$504 \$1112 \$1116 \$1136 GND nfet_03v3 L=0.28U W=0.44U AS=0.2684P AD=0.2684P
+ PS=2.1U PD=2.1U
R$505 \$1085 VDD GND 20000 ppolyf_u_1k L=20U W=1U
R$506 \$1086 VDD GND 20000 ppolyf_u_1k L=20U W=1U
R$507 \$1087 VDD GND 20000 ppolyf_u_1k L=20U W=1U
R$508 \$1088 VDD GND 20000 ppolyf_u_1k L=20U W=1U
R$509 \$1089 VDD GND 20000 ppolyf_u_1k L=20U W=1U
R$510 \$1090 VDD GND 20000 ppolyf_u_1k L=20U W=1U
R$511 \$1091 VDD GND 20000 ppolyf_u_1k L=20U W=1U
R$512 \$1092 VDD GND 20000 ppolyf_u_1k L=20U W=1U
R$513 \$1093 VDD GND 20000 ppolyf_u_1k L=20U W=1U
R$514 \$1094 VDD GND 20000 ppolyf_u_1k L=20U W=1U
R$515 \$1096 VDD GND 20000 ppolyf_u_1k L=20U W=1U
R$516 \$1097 VDD GND 20000 ppolyf_u_1k L=20U W=1U
.ENDS rom2
