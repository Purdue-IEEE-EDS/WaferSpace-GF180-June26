** sch_path: /foss/designs/WaferSpace-GF180-June26/blocks/adc/encoder/sym/ROM2.sch
.subckt ROM2 VDD IN0 IN1 IN2 IN3 IN4 IN5 IN6 IN7 IN8 IN9 IN10 IN11 IN12 IN13 IN14 IN15 IN16 IN17 IN18 IN19 IN20 IN21 IN22 IN23
+ IN24 IN25 IN26 IN27 IN28 IN29 IN30 IN32 IN33 IN34 IN35 IN36 IN37 IN38 IN39 IN40 IN41 IN42 IN43 IN44 IN45 IN46 IN47 IN48 IN49 IN50 IN51
+ IN52 IN53 IN54 IN55 IN56 IN57 IN58 IN59 IN60 IN61 IN62 B4 B0 B1 B2 B3 GND THERMOMETER_31
*.PININFO IN0:I IN1:I IN2:I IN3:I IN4:I IN5:I IN6:I IN7:I IN8:I IN9:I IN10:I IN11:I IN12:I IN13:I IN14:I IN15:I IN16:I IN17:I
*+ IN18:I IN19:I IN20:I IN21:I IN22:I IN23:I IN24:I IN25:I IN26:I IN27:I IN28:I IN29:I IN30:I IN32:I IN33:I IN34:I IN35:I IN36:I IN37:I
*+ IN38:I IN39:I IN40:I IN41:I IN42:I IN43:I IN44:I IN45:I IN46:I IN47:I IN48:I IN49:I IN50:I IN51:I IN52:I IN53:I IN54:I IN55:I IN56:I
*+ IN57:I IN58:I IN59:I IN60:I IN61:I IN62:I B4:O B3:O B2:O B1:O B0:O THERMOMETER_31:I B5:O VDD:I GND:I
M218 B0bar IN0 GND GND nfet_03v3 L=0.28u W=0.44u nf=1
M219 B0bar IN2 GND GND nfet_03v3 L=0.28u W=0.44u nf=1
M220 B0bar IN4 GND GND nfet_03v3 L=0.28u W=0.44u nf=1
M221 B1bar IN2 GND GND nfet_03v3 L=0.28u W=0.44u nf=1
M222 B1bar IN1 GND GND nfet_03v3 L=0.28u W=0.44u nf=1
M223 B1bar IN5 GND GND nfet_03v3 L=0.28u W=0.44u nf=1
M224 B0bar IN6 GND GND nfet_03v3 L=0.28u W=0.44u nf=1
M225 B1bar IN6 GND GND nfet_03v3 L=0.28u W=0.44u nf=1
M226 B2bar IN4 GND GND nfet_03v3 L=0.28u W=0.44u nf=1
M227 B2bar IN3 GND GND nfet_03v3 L=0.28u W=0.44u nf=1
M228 B2bar IN6 GND GND nfet_03v3 L=0.28u W=0.44u nf=1
M229 B2bar IN5 GND GND nfet_03v3 L=0.28u W=0.44u nf=1
M230 B0bar IN8 GND GND nfet_03v3 L=0.28u W=0.44u nf=1
M231 B0bar IN10 GND GND nfet_03v3 L=0.28u W=0.44u nf=1
M232 B0bar IN12 GND GND nfet_03v3 L=0.28u W=0.44u nf=1
M233 B1bar IN10 GND GND nfet_03v3 L=0.28u W=0.44u nf=1
M234 B1bar IN9 GND GND nfet_03v3 L=0.28u W=0.44u nf=1
M235 B1bar IN13 GND GND nfet_03v3 L=0.28u W=0.44u nf=1
M236 B0bar IN14 GND GND nfet_03v3 L=0.28u W=0.44u nf=1
M237 B1bar IN14 GND GND nfet_03v3 L=0.28u W=0.44u nf=1
M238 B2bar IN12 GND GND nfet_03v3 L=0.28u W=0.44u nf=1
M239 B2bar IN11 GND GND nfet_03v3 L=0.28u W=0.44u nf=1
M240 B2bar IN14 GND GND nfet_03v3 L=0.28u W=0.44u nf=1
M241 B2bar IN13 GND GND nfet_03v3 L=0.28u W=0.44u nf=1
M242 B3bar IN8 GND GND nfet_03v3 L=0.28u W=0.44u nf=1
M243 B3bar IN7 GND GND nfet_03v3 L=0.28u W=0.44u nf=1
M244 B3bar IN10 GND GND nfet_03v3 L=0.28u W=0.44u nf=1
M245 B3bar IN9 GND GND nfet_03v3 L=0.28u W=0.44u nf=1
M246 B3bar IN12 GND GND nfet_03v3 L=0.28u W=0.44u nf=1
M247 B3bar IN11 GND GND nfet_03v3 L=0.28u W=0.44u nf=1
M248 B3bar IN14 GND GND nfet_03v3 L=0.28u W=0.44u nf=1
M249 B3bar IN13 GND GND nfet_03v3 L=0.28u W=0.44u nf=1
M250 B4bar IN15 GND GND nfet_03v3 L=0.28u W=0.44u nf=1
M251 B0bar IN16 GND GND nfet_03v3 L=0.28u W=0.44u nf=1
M252 B0bar IN18 GND GND nfet_03v3 L=0.28u W=0.44u nf=1
M253 B0bar IN20 GND GND nfet_03v3 L=0.28u W=0.44u nf=1
M254 B1bar IN18 GND GND nfet_03v3 L=0.28u W=0.44u nf=1
M255 B1bar IN17 GND GND nfet_03v3 L=0.28u W=0.44u nf=1
M256 B1bar IN21 GND GND nfet_03v3 L=0.28u W=0.44u nf=1
M257 B0bar IN22 GND GND nfet_03v3 L=0.28u W=0.44u nf=1
M258 B1bar IN22 GND GND nfet_03v3 L=0.28u W=0.44u nf=1
M259 B2bar IN20 GND GND nfet_03v3 L=0.28u W=0.44u nf=1
M260 B2bar IN19 GND GND nfet_03v3 L=0.28u W=0.44u nf=1
M261 B2bar IN22 GND GND nfet_03v3 L=0.28u W=0.44u nf=1
M262 B2bar IN21 GND GND nfet_03v3 L=0.28u W=0.44u nf=1
M263 B0bar IN24 GND GND nfet_03v3 L=0.28u W=0.44u nf=1
M264 B0bar IN26 GND GND nfet_03v3 L=0.28u W=0.44u nf=1
M265 B0bar IN28 GND GND nfet_03v3 L=0.28u W=0.44u nf=1
M266 B1bar IN26 GND GND nfet_03v3 L=0.28u W=0.44u nf=1
M267 B1bar IN25 GND GND nfet_03v3 L=0.28u W=0.44u nf=1
M268 B1bar IN29 GND GND nfet_03v3 L=0.28u W=0.44u nf=1
M269 B0bar IN30 GND GND nfet_03v3 L=0.28u W=0.44u nf=1
M270 B1bar IN30 GND GND nfet_03v3 L=0.28u W=0.44u nf=1
M271 B2bar IN28 GND GND nfet_03v3 L=0.28u W=0.44u nf=1
M272 B2bar IN27 GND GND nfet_03v3 L=0.28u W=0.44u nf=1
M273 B2bar IN30 GND GND nfet_03v3 L=0.28u W=0.44u nf=1
M274 B2bar IN29 GND GND nfet_03v3 L=0.28u W=0.44u nf=1
M275 B3bar IN24 GND GND nfet_03v3 L=0.28u W=0.44u nf=1
M276 B3bar IN23 GND GND nfet_03v3 L=0.28u W=0.44u nf=1
M277 B3bar IN26 GND GND nfet_03v3 L=0.28u W=0.44u nf=1
M278 B3bar IN25 GND GND nfet_03v3 L=0.28u W=0.44u nf=1
M279 B3bar IN28 GND GND nfet_03v3 L=0.28u W=0.44u nf=1
M280 B3bar IN27 GND GND nfet_03v3 L=0.28u W=0.44u nf=1
M281 B3bar IN30 GND GND nfet_03v3 L=0.28u W=0.44u nf=1
M282 B3bar IN29 GND GND nfet_03v3 L=0.28u W=0.44u nf=1
M283 B0bar_h IN32 GND GND nfet_03v3 L=0.28u W=0.44u nf=1
M284 B0bar_h IN34 GND GND nfet_03v3 L=0.28u W=0.44u nf=1
M285 B0bar_h IN36 GND GND nfet_03v3 L=0.28u W=0.44u nf=1
M286 B1bar_h IN34 GND GND nfet_03v3 L=0.28u W=0.44u nf=1
M287 B1bar_h IN33 GND GND nfet_03v3 L=0.28u W=0.44u nf=1
M288 B1bar_h IN37 GND GND nfet_03v3 L=0.28u W=0.44u nf=1
M289 B0bar_h IN38 GND GND nfet_03v3 L=0.28u W=0.44u nf=1
M290 B1bar_h IN38 GND GND nfet_03v3 L=0.28u W=0.44u nf=1
M291 B2bar_h IN36 GND GND nfet_03v3 L=0.28u W=0.44u nf=1
M292 B2bar_h IN35 GND GND nfet_03v3 L=0.28u W=0.44u nf=1
M293 B2bar_h IN38 GND GND nfet_03v3 L=0.28u W=0.44u nf=1
M294 B2bar_h IN37 GND GND nfet_03v3 L=0.28u W=0.44u nf=1
M295 B0bar_h IN40 GND GND nfet_03v3 L=0.28u W=0.44u nf=1
M296 B0bar_h IN42 GND GND nfet_03v3 L=0.28u W=0.44u nf=1
M297 B0bar_h IN44 GND GND nfet_03v3 L=0.28u W=0.44u nf=1
M298 B1bar_h IN42 GND GND nfet_03v3 L=0.28u W=0.44u nf=1
M299 B1bar_h IN41 GND GND nfet_03v3 L=0.28u W=0.44u nf=1
M300 B1bar_h IN45 GND GND nfet_03v3 L=0.28u W=0.44u nf=1
M301 B0bar_h IN46 GND GND nfet_03v3 L=0.28u W=0.44u nf=1
M302 B1bar_h IN46 GND GND nfet_03v3 L=0.28u W=0.44u nf=1
M303 B2bar_h IN44 GND GND nfet_03v3 L=0.28u W=0.44u nf=1
M304 B2bar_h IN43 GND GND nfet_03v3 L=0.28u W=0.44u nf=1
M305 B2bar_h IN46 GND GND nfet_03v3 L=0.28u W=0.44u nf=1
M306 B2bar_h IN45 GND GND nfet_03v3 L=0.28u W=0.44u nf=1
M307 B3bar_h IN40 GND GND nfet_03v3 L=0.28u W=0.44u nf=1
M308 B3bar_h IN39 GND GND nfet_03v3 L=0.28u W=0.44u nf=1
M309 B3bar_h IN42 GND GND nfet_03v3 L=0.28u W=0.44u nf=1
M310 B3bar_h IN41 GND GND nfet_03v3 L=0.28u W=0.44u nf=1
M311 B3bar_h IN44 GND GND nfet_03v3 L=0.28u W=0.44u nf=1
M312 B3bar_h IN43 GND GND nfet_03v3 L=0.28u W=0.44u nf=1
M313 B3bar_h IN46 GND GND nfet_03v3 L=0.28u W=0.44u nf=1
M314 B3bar_h IN45 GND GND nfet_03v3 L=0.28u W=0.44u nf=1
M315 B0bar_h IN48 GND GND nfet_03v3 L=0.28u W=0.44u nf=1
M316 B0bar_h IN50 GND GND nfet_03v3 L=0.28u W=0.44u nf=1
M317 B0bar_h IN52 GND GND nfet_03v3 L=0.28u W=0.44u nf=1
M318 B1bar_h IN50 GND GND nfet_03v3 L=0.28u W=0.44u nf=1
M319 B1bar_h IN49 GND GND nfet_03v3 L=0.28u W=0.44u nf=1
M320 B1bar_h IN53 GND GND nfet_03v3 L=0.28u W=0.44u nf=1
M321 B0bar_h IN54 GND GND nfet_03v3 L=0.28u W=0.44u nf=1
M322 B1bar_h IN54 GND GND nfet_03v3 L=0.28u W=0.44u nf=1
M323 B2bar_h IN52 GND GND nfet_03v3 L=0.28u W=0.44u nf=1
M324 B2bar_h IN51 GND GND nfet_03v3 L=0.28u W=0.44u nf=1
M325 B2bar_h IN54 GND GND nfet_03v3 L=0.28u W=0.44u nf=1
M326 B2bar_h IN53 GND GND nfet_03v3 L=0.28u W=0.44u nf=1
M327 B0bar_h IN56 GND GND nfet_03v3 L=0.28u W=0.44u nf=1
M328 B0bar_h IN58 GND GND nfet_03v3 L=0.28u W=0.44u nf=1
M329 B0bar_h IN60 GND GND nfet_03v3 L=0.28u W=0.44u nf=1
M330 B1bar_h IN58 GND GND nfet_03v3 L=0.28u W=0.44u nf=1
M331 B1bar_h IN57 GND GND nfet_03v3 L=0.28u W=0.44u nf=1
M332 B1bar_h IN61 GND GND nfet_03v3 L=0.28u W=0.44u nf=1
M333 B0bar_h IN62 GND GND nfet_03v3 L=0.28u W=0.44u nf=1
M334 B1bar_h IN62 GND GND nfet_03v3 L=0.28u W=0.44u nf=1
M335 B2bar_h IN60 GND GND nfet_03v3 L=0.28u W=0.44u nf=1
M336 B2bar_h IN59 GND GND nfet_03v3 L=0.28u W=0.44u nf=1
M337 B2bar_h IN62 GND GND nfet_03v3 L=0.28u W=0.44u nf=1
M338 B2bar_h IN61 GND GND nfet_03v3 L=0.28u W=0.44u nf=1
M339 B3bar_h IN56 GND GND nfet_03v3 L=0.28u W=0.44u nf=1
M340 B3bar_h IN55 GND GND nfet_03v3 L=0.28u W=0.44u nf=1
M341 B3bar_h IN58 GND GND nfet_03v3 L=0.28u W=0.44u nf=1
M342 B3bar_h IN57 GND GND nfet_03v3 L=0.28u W=0.44u nf=1
M343 B3bar_h IN60 GND GND nfet_03v3 L=0.28u W=0.44u nf=1
M344 B3bar_h IN59 GND GND nfet_03v3 L=0.28u W=0.44u nf=1
M345 B3bar_h IN62 GND GND nfet_03v3 L=0.28u W=0.44u nf=1
M346 B3bar_h IN61 GND GND nfet_03v3 L=0.28u W=0.44u nf=1
M347 B4bar IN17 GND GND nfet_03v3 L=0.28u W=0.44u nf=1
M348 B4bar IN16 GND GND nfet_03v3 L=0.28u W=0.44u nf=1
M349 B4bar IN19 GND GND nfet_03v3 L=0.28u W=0.44u nf=1
M350 B4bar IN18 GND GND nfet_03v3 L=0.28u W=0.44u nf=1
M351 B4bar IN21 GND GND nfet_03v3 L=0.28u W=0.44u nf=1
M352 B4bar IN20 GND GND nfet_03v3 L=0.28u W=0.44u nf=1
M353 B4bar IN22 GND GND nfet_03v3 L=0.28u W=0.44u nf=1
M354 B4bar IN23 GND GND nfet_03v3 L=0.28u W=0.44u nf=1
M355 B4bar IN25 GND GND nfet_03v3 L=0.28u W=0.44u nf=1
M356 B4bar IN24 GND GND nfet_03v3 L=0.28u W=0.44u nf=1
M357 B4bar IN27 GND GND nfet_03v3 L=0.28u W=0.44u nf=1
M358 B4bar IN26 GND GND nfet_03v3 L=0.28u W=0.44u nf=1
M359 B4bar IN29 GND GND nfet_03v3 L=0.28u W=0.44u nf=1
M360 B4bar IN28 GND GND nfet_03v3 L=0.28u W=0.44u nf=1
M361 B4bar IN30 GND GND nfet_03v3 L=0.28u W=0.44u nf=1
M362 B4bar_h IN47 GND GND nfet_03v3 L=0.28u W=0.44u nf=1
M363 B4bar_h IN49 GND GND nfet_03v3 L=0.28u W=0.44u nf=1
M364 B4bar_h IN48 GND GND nfet_03v3 L=0.28u W=0.44u nf=1
M365 B4bar_h IN51 GND GND nfet_03v3 L=0.28u W=0.44u nf=1
M366 B4bar_h IN50 GND GND nfet_03v3 L=0.28u W=0.44u nf=1
M367 B4bar_h IN53 GND GND nfet_03v3 L=0.28u W=0.44u nf=1
M368 B4bar_h IN52 GND GND nfet_03v3 L=0.28u W=0.44u nf=1
M369 B4bar_h IN54 GND GND nfet_03v3 L=0.28u W=0.44u nf=1
M370 B4bar_h IN55 GND GND nfet_03v3 L=0.28u W=0.44u nf=1
M371 B4bar_h IN57 GND GND nfet_03v3 L=0.28u W=0.44u nf=1
M372 B4bar_h IN56 GND GND nfet_03v3 L=0.28u W=0.44u nf=1
M373 B4bar_h IN59 GND GND nfet_03v3 L=0.28u W=0.44u nf=1
M374 B4bar_h IN58 GND GND nfet_03v3 L=0.28u W=0.44u nf=1
M375 B4bar_h IN61 GND GND nfet_03v3 L=0.28u W=0.44u nf=1
M376 B4bar_h IN60 GND GND nfet_03v3 L=0.28u W=0.44u nf=1
M377 B4bar_h IN62 GND GND nfet_03v3 L=0.28u W=0.44u nf=1
M423 B4 B4bar_mux VDD VDD pfet_03v3 L=0.28u W=1.32u nf=3
M424 B4 B4bar_mux GND GND nfet_03v3 L=0.28u W=0.44u nf=1
M425 B3 B3bar_mux VDD VDD pfet_03v3 L=0.28u W=1.32u nf=3
M426 B3 B3bar_mux GND GND nfet_03v3 L=0.28u W=0.44u nf=1
M427 B2 B2bar_mux VDD VDD pfet_03v3 L=0.28u W=1.32u nf=3
M428 B2 B2bar_mux GND GND nfet_03v3 L=0.28u W=0.44u nf=1
M429 B1 B1bar_mux VDD VDD pfet_03v3 L=0.28u W=1.32u nf=3
M430 B1 B1bar_mux GND GND nfet_03v3 L=0.28u W=0.44u nf=1
M431 B0 B0bar_mux VDD VDD pfet_03v3 L=0.28u W=1.32u nf=3
M432 B0 B0bar_mux GND GND nfet_03v3 L=0.28u W=0.44u nf=1
XR1 B4bar VDD GND ppolyf_u_1k r_width=1e-6 r_length=2e-5
XR2 B3bar VDD GND ppolyf_u_1k r_width=1e-6 r_length=2e-5
XR3 B2bar VDD GND ppolyf_u_1k r_width=1e-6 r_length=2e-5
XR4 B1bar VDD GND ppolyf_u_1k r_width=1e-6 r_length=2e-5
XR5 B0bar VDD GND ppolyf_u_1k r_width=1e-6 r_length=2e-5
XR7 B4bar_h VDD GND ppolyf_u_1k r_width=1e-6 r_length=2e-5
XR8 B3bar_h VDD GND ppolyf_u_1k r_width=1e-6 r_length=2e-5
XR9 B2bar_h VDD GND ppolyf_u_1k r_width=1e-6 r_length=2e-5
XR10 B1bar_h VDD GND ppolyf_u_1k r_width=1e-6 r_length=2e-5
XR11 B0bar_h VDD GND ppolyf_u_1k r_width=1e-6 r_length=2e-5
M6 B4bar_mux THERMOMETER_31bar B4bar_h VDD pfet_03v3 L=0.28u W=1.32u nf=3
M7 B4bar_h THERMOMETER_31 B4bar_mux GND nfet_03v3 L=0.28u W=0.44u nf=1
M8 B3bar_mux THERMOMETER_31bar B3bar_h VDD pfet_03v3 L=0.28u W=1.32u nf=3
M9 B3bar_h THERMOMETER_31 B3bar_mux GND nfet_03v3 L=0.28u W=0.44u nf=1
M10 B2bar_h THERMOMETER_31bar B2bar_mux VDD pfet_03v3 L=0.28u W=1.32u nf=3
M11 B2bar_h THERMOMETER_31 B2bar_mux GND nfet_03v3 L=0.28u W=0.44u nf=1
M12 B1bar_mux THERMOMETER_31bar B1bar_h VDD pfet_03v3 L=0.28u W=1.32u nf=3
M13 B1bar_h THERMOMETER_31 B1bar_mux GND nfet_03v3 L=0.28u W=0.44u nf=1
M14 B0bar_h THERMOMETER_31bar B0bar_mux VDD pfet_03v3 L=0.28u W=1.32u nf=3
M15 B0bar_h THERMOMETER_31 B0bar_mux GND nfet_03v3 L=0.28u W=0.44u nf=1
M16 B4bar_mux THERMOMETER_31 B4bar VDD pfet_03v3 L=0.28u W=1.32u nf=3
M17 B4bar THERMOMETER_31bar B4bar_mux GND nfet_03v3 L=0.28u W=0.44u nf=1
M18 B3bar_mux THERMOMETER_31 B3bar VDD pfet_03v3 L=0.28u W=1.32u nf=3
M19 B3bar THERMOMETER_31bar B3bar_mux GND nfet_03v3 L=0.28u W=0.44u nf=1
M20 B2bar THERMOMETER_31 B2bar_mux VDD pfet_03v3 L=0.28u W=1.32u nf=3
M21 B2bar THERMOMETER_31bar B2bar_mux GND nfet_03v3 L=0.28u W=0.44u nf=1
M22 B1bar_mux THERMOMETER_31 B1bar VDD pfet_03v3 L=0.28u W=1.32u nf=3
M23 B1bar THERMOMETER_31bar B1bar_mux GND nfet_03v3 L=0.28u W=0.44u nf=1
M24 B0bar THERMOMETER_31 B0bar_mux VDD pfet_03v3 L=0.28u W=1.32u nf=3
M25 B0bar THERMOMETER_31bar B0bar_mux GND nfet_03v3 L=0.28u W=0.44u nf=1
M26 THERMOMETER_31bar THERMOMETER_31 VDD VDD pfet_03v3 L=0.28u W=1.32u nf=3
M27 THERMOMETER_31bar THERMOMETER_31 GND GND nfet_03v3 L=0.28u W=0.44u nf=1
.ends
