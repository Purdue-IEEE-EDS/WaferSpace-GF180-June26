* Extracted by KLayout with GF180MCU LVS runset on : 18/06/2026 21:51

.SUBCKT NAND3 GND out B A C VDD
M$1 \$2 C VDD VDD pfet_03v3 L=0.28U W=2U AS=1.3P AD=1.3P PS=5.3U PD=5.3U
M$2 \$3 A VDD VDD pfet_03v3 L=0.28U W=2U AS=1.3P AD=0.84P PS=5.3U PD=2.84U
M$3 VDD B \$3 VDD pfet_03v3 L=0.28U W=2U AS=0.84P AD=0.84P PS=2.84U PD=2.84U
M$4 \$3 \$2 VDD VDD pfet_03v3 L=0.28U W=2U AS=0.84P AD=1.3P PS=2.84U PD=5.3U
M$5 VDD \$3 out VDD pfet_03v3 L=0.28U W=2U AS=1.3P AD=1.3P PS=5.3U PD=5.3U
M$6 \$2 C GND GND nfet_03v3 L=0.28U W=1U AS=0.61P AD=0.61P PS=3.22U PD=3.22U
M$7 \$4 A \$3 GND nfet_03v3 L=0.28U W=1U AS=0.61P AD=0.4P PS=3.22U PD=1.8U
M$8 \$5 B \$4 GND nfet_03v3 L=0.28U W=1U AS=0.4P AD=0.4P PS=1.8U PD=1.8U
M$9 GND \$2 \$5 GND nfet_03v3 L=0.28U W=1U AS=0.4P AD=0.61P PS=1.8U PD=3.22U
M$10 GND \$3 out GND nfet_03v3 L=0.28U W=1U AS=0.61P AD=0.61P PS=3.22U PD=3.22U
.ENDS NAND3
