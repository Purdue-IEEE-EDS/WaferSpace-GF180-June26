* Extracted by KLayout with GF180MCU LVS runset on : 01/06/2026 21:23

.SUBCKT tm_to_bin2 OUT|wl[0] comp[1] VDD OUT|wl[1] A_3|comp[2] GND OUT|wl[2]
+ A_4|B_3|comp[3] OUT|wl[3] A_5|B_4|C_3|comp[4] OUT|wl[4] A_6|B_5|C_4|comp[5]
+ OUT|wl[5] B_6|C_5|comp[6] OUT|wl[6] C_6|comp[7] OUT|wl[7] comp[8] OUT|wl[8]
+ comp[9] OUT|wl[9] comp[10] OUT|wl[10] comp[11] OUT|wl[11] comp[12] OUT|wl[12]
+ comp[13] OUT|wl[13] VDD|comp[14] OUT|wl[14] comp[15] OUT|wl[15] comp[16]
+ OUT|wl[16] comp[17] OUT|wl[17] comp[18] OUT|wl[18] comp[19] OUT|wl[19]
+ comp[20] OUT|wl[20] comp[21] OUT|wl[21] comp[22] OUT|wl[22] comp[23]
+ OUT|wl[23] comp[24] OUT|wl[24] comp[25] OUT|wl[25] comp[26] OUT|wl[26]
+ comp[27] OUT|wl[27] comp[28] OUT|wl[28] comp[29] OUT|wl[29] comp[30]
+ OUT|wl[30] comp[31] OUT|wl[31] comp[32] OUT|wl[32] comp[33] OUT|wl[33]
+ comp[34] OUT|wl[34] comp[35] OUT|wl[35] comp[36] OUT|wl[36] comp[37]
+ OUT|wl[37] comp[38] OUT|wl[38] comp[39] OUT|wl[39] comp[40] OUT|wl[40]
+ comp[41] OUT|wl[41] comp[42] OUT|wl[42] comp[43] OUT|wl[43] comp[44]
+ OUT|wl[44] comp[45] OUT|wl[45] comp[46] OUT|wl[46] comp[47] OUT|wl[47]
+ comp[48] OUT|wl[48] comp[49] OUT|wl[49] comp[50] OUT|wl[50] comp[51]
+ OUT|wl[51] comp[52] OUT|wl[52] comp[53] OUT|wl[53] comp[54] OUT|wl[54]
+ comp[55] OUT|wl[55] comp[56] OUT|wl[56] comp[57] OUT|wl[57] comp[58]
+ OUT|wl[58] comp[59] OUT|wl[59] comp[60] OUT|wl[60] comp[61] OUT|wl[61]
+ comp[62] OUT|wl[62]
M$1 VDD VDD \$5 VDD pfet_03v3 L=0.28U W=16.5U AS=5.577P AD=5.577P PS=23.18U
+ PD=23.18U
M$6 VDD \$8 \$5 VDD pfet_03v3 L=0.28U W=16.5U AS=5.577P AD=5.577P PS=23.18U
+ PD=23.18U
M$11 VDD \$10 \$5 VDD pfet_03v3 L=0.28U W=16.5U AS=5.577P AD=5.577P PS=23.18U
+ PD=23.18U
M$16 VDD comp[1] \$10 VDD pfet_03v3 L=0.28U W=16.5U AS=5.577P AD=5.577P
+ PS=23.18U PD=23.18U
M$21 VDD \$5 OUT|wl[0] VDD pfet_03v3 L=0.28U W=16.5U AS=5.577P AD=5.577P
+ PS=23.18U PD=23.18U
M$26 VDD \$8 \$24 VDD pfet_03v3 L=0.28U W=16.5U AS=5.577P AD=5.577P PS=23.18U
+ PD=23.18U
M$31 VDD comp[1] \$24 VDD pfet_03v3 L=0.28U W=16.5U AS=5.577P AD=5.577P
+ PS=23.18U PD=23.18U
M$36 VDD \$25 \$24 VDD pfet_03v3 L=0.28U W=16.5U AS=5.577P AD=5.577P PS=23.18U
+ PD=23.18U
M$41 VDD A_3|comp[2] \$25 VDD pfet_03v3 L=0.28U W=16.5U AS=5.577P AD=5.577P
+ PS=23.18U PD=23.18U
M$46 VDD \$24 OUT|wl[1] VDD pfet_03v3 L=0.28U W=16.5U AS=5.577P AD=5.577P
+ PS=23.18U PD=23.18U
M$51 VDD comp[1] \$47 VDD pfet_03v3 L=0.28U W=16.5U AS=5.577P AD=5.577P
+ PS=23.18U PD=23.18U
M$56 VDD A_3|comp[2] \$47 VDD pfet_03v3 L=0.28U W=16.5U AS=5.577P AD=5.577P
+ PS=23.18U PD=23.18U
M$61 VDD \$44 \$47 VDD pfet_03v3 L=0.28U W=16.5U AS=5.577P AD=5.577P PS=23.18U
+ PD=23.18U
M$66 VDD A_4|B_3|comp[3] \$44 VDD pfet_03v3 L=0.28U W=16.5U AS=5.577P AD=5.577P
+ PS=23.18U PD=23.18U
M$71 VDD \$47 OUT|wl[2] VDD pfet_03v3 L=0.28U W=16.5U AS=5.577P AD=5.577P
+ PS=23.18U PD=23.18U
M$76 VDD A_3|comp[2] \$59 VDD pfet_03v3 L=0.28U W=16.5U AS=5.577P AD=5.577P
+ PS=23.18U PD=23.18U
M$81 VDD A_4|B_3|comp[3] \$59 VDD pfet_03v3 L=0.28U W=16.5U AS=5.577P AD=5.577P
+ PS=23.18U PD=23.18U
M$86 VDD \$60 \$59 VDD pfet_03v3 L=0.28U W=16.5U AS=5.577P AD=5.577P PS=23.18U
+ PD=23.18U
M$91 VDD A_5|B_4|C_3|comp[4] \$60 VDD pfet_03v3 L=0.28U W=16.5U AS=5.577P
+ AD=5.577P PS=23.18U PD=23.18U
M$96 VDD \$59 OUT|wl[3] VDD pfet_03v3 L=0.28U W=16.5U AS=5.577P AD=5.577P
+ PS=23.18U PD=23.18U
M$101 VDD A_4|B_3|comp[3] \$81 VDD pfet_03v3 L=0.28U W=16.5U AS=5.577P
+ AD=5.577P PS=23.18U PD=23.18U
M$106 VDD A_5|B_4|C_3|comp[4] \$81 VDD pfet_03v3 L=0.28U W=16.5U AS=5.577P
+ AD=5.577P PS=23.18U PD=23.18U
M$111 VDD \$78 \$81 VDD pfet_03v3 L=0.28U W=16.5U AS=5.577P AD=5.577P PS=23.18U
+ PD=23.18U
M$116 VDD A_6|B_5|C_4|comp[5] \$78 VDD pfet_03v3 L=0.28U W=16.5U AS=5.577P
+ AD=5.577P PS=23.18U PD=23.18U
M$121 VDD \$81 OUT|wl[4] VDD pfet_03v3 L=0.28U W=16.5U AS=5.577P AD=5.577P
+ PS=23.18U PD=23.18U
M$126 VDD A_5|B_4|C_3|comp[4] \$93 VDD pfet_03v3 L=0.28U W=16.5U AS=5.577P
+ AD=5.577P PS=23.18U PD=23.18U
M$131 VDD A_6|B_5|C_4|comp[5] \$93 VDD pfet_03v3 L=0.28U W=16.5U AS=5.577P
+ AD=5.577P PS=23.18U PD=23.18U
M$136 VDD \$94 \$93 VDD pfet_03v3 L=0.28U W=16.5U AS=5.577P AD=5.577P PS=23.18U
+ PD=23.18U
M$141 VDD B_6|C_5|comp[6] \$94 VDD pfet_03v3 L=0.28U W=16.5U AS=5.577P
+ AD=5.577P PS=23.18U PD=23.18U
M$146 VDD \$93 OUT|wl[5] VDD pfet_03v3 L=0.28U W=16.5U AS=5.577P AD=5.577P
+ PS=23.18U PD=23.18U
M$151 VDD A_6|B_5|C_4|comp[5] \$115 VDD pfet_03v3 L=0.28U W=16.5U AS=5.577P
+ AD=5.577P PS=23.18U PD=23.18U
M$156 VDD B_6|C_5|comp[6] \$115 VDD pfet_03v3 L=0.28U W=16.5U AS=5.577P
+ AD=5.577P PS=23.18U PD=23.18U
M$161 VDD \$112 \$115 VDD pfet_03v3 L=0.28U W=16.5U AS=5.577P AD=5.577P
+ PS=23.18U PD=23.18U
M$166 VDD C_6|comp[7] \$112 VDD pfet_03v3 L=0.28U W=16.5U AS=5.577P AD=5.577P
+ PS=23.18U PD=23.18U
M$171 VDD \$115 OUT|wl[6] VDD pfet_03v3 L=0.28U W=16.5U AS=5.577P AD=5.577P
+ PS=23.18U PD=23.18U
M$176 VDD B_6|C_5|comp[6] \$127 VDD pfet_03v3 L=0.28U W=16.5U AS=5.577P
+ AD=5.577P PS=23.18U PD=23.18U
M$181 VDD C_6|comp[7] \$127 VDD pfet_03v3 L=0.28U W=16.5U AS=5.577P AD=5.577P
+ PS=23.18U PD=23.18U
M$186 VDD \$128 \$127 VDD pfet_03v3 L=0.28U W=16.5U AS=5.577P AD=5.577P
+ PS=23.18U PD=23.18U
M$191 VDD comp[8] \$128 VDD pfet_03v3 L=0.28U W=16.5U AS=5.577P AD=5.577P
+ PS=23.18U PD=23.18U
M$196 VDD \$127 OUT|wl[7] VDD pfet_03v3 L=0.28U W=16.5U AS=5.577P AD=5.577P
+ PS=23.18U PD=23.18U
M$201 VDD C_6|comp[7] \$149 VDD pfet_03v3 L=0.28U W=16.5U AS=5.577P AD=5.577P
+ PS=23.18U PD=23.18U
M$206 VDD comp[8] \$149 VDD pfet_03v3 L=0.28U W=16.5U AS=5.577P AD=5.577P
+ PS=23.18U PD=23.18U
M$211 VDD \$146 \$149 VDD pfet_03v3 L=0.28U W=16.5U AS=5.577P AD=5.577P
+ PS=23.18U PD=23.18U
M$216 VDD comp[9] \$146 VDD pfet_03v3 L=0.28U W=16.5U AS=5.577P AD=5.577P
+ PS=23.18U PD=23.18U
M$221 VDD \$149 OUT|wl[8] VDD pfet_03v3 L=0.28U W=16.5U AS=5.577P AD=5.577P
+ PS=23.18U PD=23.18U
M$226 VDD comp[8] \$161 VDD pfet_03v3 L=0.28U W=16.5U AS=5.577P AD=5.577P
+ PS=23.18U PD=23.18U
M$231 VDD comp[9] \$161 VDD pfet_03v3 L=0.28U W=16.5U AS=5.577P AD=5.577P
+ PS=23.18U PD=23.18U
M$236 VDD \$162 \$161 VDD pfet_03v3 L=0.28U W=16.5U AS=5.577P AD=5.577P
+ PS=23.18U PD=23.18U
M$241 VDD comp[10] \$162 VDD pfet_03v3 L=0.28U W=16.5U AS=5.577P AD=5.577P
+ PS=23.18U PD=23.18U
M$246 VDD \$161 OUT|wl[9] VDD pfet_03v3 L=0.28U W=16.5U AS=5.577P AD=5.577P
+ PS=23.18U PD=23.18U
M$251 VDD comp[9] \$183 VDD pfet_03v3 L=0.28U W=16.5U AS=5.577P AD=5.577P
+ PS=23.18U PD=23.18U
M$256 VDD comp[10] \$183 VDD pfet_03v3 L=0.28U W=16.5U AS=5.577P AD=5.577P
+ PS=23.18U PD=23.18U
M$261 VDD \$180 \$183 VDD pfet_03v3 L=0.28U W=16.5U AS=5.577P AD=5.577P
+ PS=23.18U PD=23.18U
M$266 VDD comp[11] \$180 VDD pfet_03v3 L=0.28U W=16.5U AS=5.577P AD=5.577P
+ PS=23.18U PD=23.18U
M$271 VDD \$183 OUT|wl[10] VDD pfet_03v3 L=0.28U W=16.5U AS=5.577P AD=5.577P
+ PS=23.18U PD=23.18U
M$276 VDD comp[10] \$195 VDD pfet_03v3 L=0.28U W=16.5U AS=5.577P AD=5.577P
+ PS=23.18U PD=23.18U
M$281 VDD comp[11] \$195 VDD pfet_03v3 L=0.28U W=16.5U AS=5.577P AD=5.577P
+ PS=23.18U PD=23.18U
M$286 VDD \$196 \$195 VDD pfet_03v3 L=0.28U W=16.5U AS=5.577P AD=5.577P
+ PS=23.18U PD=23.18U
M$291 VDD comp[12] \$196 VDD pfet_03v3 L=0.28U W=16.5U AS=5.577P AD=5.577P
+ PS=23.18U PD=23.18U
M$296 VDD \$195 OUT|wl[11] VDD pfet_03v3 L=0.28U W=16.5U AS=5.577P AD=5.577P
+ PS=23.18U PD=23.18U
M$301 VDD comp[11] \$217 VDD pfet_03v3 L=0.28U W=16.5U AS=5.577P AD=5.577P
+ PS=23.18U PD=23.18U
M$306 VDD comp[12] \$217 VDD pfet_03v3 L=0.28U W=16.5U AS=5.577P AD=5.577P
+ PS=23.18U PD=23.18U
M$311 VDD \$214 \$217 VDD pfet_03v3 L=0.28U W=16.5U AS=5.577P AD=5.577P
+ PS=23.18U PD=23.18U
M$316 VDD comp[13] \$214 VDD pfet_03v3 L=0.28U W=16.5U AS=5.577P AD=5.577P
+ PS=23.18U PD=23.18U
M$321 VDD \$217 OUT|wl[12] VDD pfet_03v3 L=0.28U W=16.5U AS=5.577P AD=5.577P
+ PS=23.18U PD=23.18U
M$326 VDD comp[12] \$229 VDD pfet_03v3 L=0.28U W=16.5U AS=5.577P AD=5.577P
+ PS=23.18U PD=23.18U
M$331 VDD comp[13] \$229 VDD pfet_03v3 L=0.28U W=16.5U AS=5.577P AD=5.577P
+ PS=23.18U PD=23.18U
M$336 VDD \$230 \$229 VDD pfet_03v3 L=0.28U W=16.5U AS=5.577P AD=5.577P
+ PS=23.18U PD=23.18U
M$341 VDD VDD|comp[14] \$230 VDD pfet_03v3 L=0.28U W=16.5U AS=5.577P AD=5.577P
+ PS=23.18U PD=23.18U
M$346 VDD \$229 OUT|wl[13] VDD pfet_03v3 L=0.28U W=16.5U AS=5.577P AD=5.577P
+ PS=23.18U PD=23.18U
M$351 VDD comp[13] \$251 VDD pfet_03v3 L=0.28U W=16.5U AS=5.577P AD=5.577P
+ PS=23.18U PD=23.18U
M$356 VDD VDD|comp[14] \$251 VDD pfet_03v3 L=0.28U W=16.5U AS=5.577P AD=5.577P
+ PS=23.18U PD=23.18U
M$361 VDD \$248 \$251 VDD pfet_03v3 L=0.28U W=16.5U AS=5.577P AD=5.577P
+ PS=23.18U PD=23.18U
M$366 VDD comp[15] \$248 VDD pfet_03v3 L=0.28U W=16.5U AS=5.577P AD=5.577P
+ PS=23.18U PD=23.18U
M$371 VDD \$251 OUT|wl[14] VDD pfet_03v3 L=0.28U W=16.5U AS=5.577P AD=5.577P
+ PS=23.18U PD=23.18U
M$376 VDD VDD|comp[14] \$263 VDD pfet_03v3 L=0.28U W=16.5U AS=5.577P AD=5.577P
+ PS=23.18U PD=23.18U
M$381 VDD comp[15] \$263 VDD pfet_03v3 L=0.28U W=16.5U AS=5.577P AD=5.577P
+ PS=23.18U PD=23.18U
M$386 VDD \$264 \$263 VDD pfet_03v3 L=0.28U W=16.5U AS=5.577P AD=5.577P
+ PS=23.18U PD=23.18U
M$391 VDD comp[16] \$264 VDD pfet_03v3 L=0.28U W=16.5U AS=5.577P AD=5.577P
+ PS=23.18U PD=23.18U
M$396 VDD \$263 OUT|wl[15] VDD pfet_03v3 L=0.28U W=16.5U AS=5.577P AD=5.577P
+ PS=23.18U PD=23.18U
M$401 VDD comp[15] \$285 VDD pfet_03v3 L=0.28U W=16.5U AS=5.577P AD=5.577P
+ PS=23.18U PD=23.18U
M$406 VDD comp[16] \$285 VDD pfet_03v3 L=0.28U W=16.5U AS=5.577P AD=5.577P
+ PS=23.18U PD=23.18U
M$411 VDD \$282 \$285 VDD pfet_03v3 L=0.28U W=16.5U AS=5.577P AD=5.577P
+ PS=23.18U PD=23.18U
M$416 VDD comp[17] \$282 VDD pfet_03v3 L=0.28U W=16.5U AS=5.577P AD=5.577P
+ PS=23.18U PD=23.18U
M$421 VDD \$285 OUT|wl[16] VDD pfet_03v3 L=0.28U W=16.5U AS=5.577P AD=5.577P
+ PS=23.18U PD=23.18U
M$426 VDD comp[16] \$297 VDD pfet_03v3 L=0.28U W=16.5U AS=5.577P AD=5.577P
+ PS=23.18U PD=23.18U
M$431 VDD comp[17] \$297 VDD pfet_03v3 L=0.28U W=16.5U AS=5.577P AD=5.577P
+ PS=23.18U PD=23.18U
M$436 VDD \$298 \$297 VDD pfet_03v3 L=0.28U W=16.5U AS=5.577P AD=5.577P
+ PS=23.18U PD=23.18U
M$441 VDD comp[18] \$298 VDD pfet_03v3 L=0.28U W=16.5U AS=5.577P AD=5.577P
+ PS=23.18U PD=23.18U
M$446 VDD \$297 OUT|wl[17] VDD pfet_03v3 L=0.28U W=16.5U AS=5.577P AD=5.577P
+ PS=23.18U PD=23.18U
M$451 VDD comp[17] \$319 VDD pfet_03v3 L=0.28U W=16.5U AS=5.577P AD=5.577P
+ PS=23.18U PD=23.18U
M$456 VDD comp[18] \$319 VDD pfet_03v3 L=0.28U W=16.5U AS=5.577P AD=5.577P
+ PS=23.18U PD=23.18U
M$461 VDD \$316 \$319 VDD pfet_03v3 L=0.28U W=16.5U AS=5.577P AD=5.577P
+ PS=23.18U PD=23.18U
M$466 VDD comp[19] \$316 VDD pfet_03v3 L=0.28U W=16.5U AS=5.577P AD=5.577P
+ PS=23.18U PD=23.18U
M$471 VDD \$319 OUT|wl[18] VDD pfet_03v3 L=0.28U W=16.5U AS=5.577P AD=5.577P
+ PS=23.18U PD=23.18U
M$476 VDD comp[18] \$331 VDD pfet_03v3 L=0.28U W=16.5U AS=5.577P AD=5.577P
+ PS=23.18U PD=23.18U
M$481 VDD comp[19] \$331 VDD pfet_03v3 L=0.28U W=16.5U AS=5.577P AD=5.577P
+ PS=23.18U PD=23.18U
M$486 VDD \$332 \$331 VDD pfet_03v3 L=0.28U W=16.5U AS=5.577P AD=5.577P
+ PS=23.18U PD=23.18U
M$491 VDD comp[20] \$332 VDD pfet_03v3 L=0.28U W=16.5U AS=5.577P AD=5.577P
+ PS=23.18U PD=23.18U
M$496 VDD \$331 OUT|wl[19] VDD pfet_03v3 L=0.28U W=16.5U AS=5.577P AD=5.577P
+ PS=23.18U PD=23.18U
M$501 VDD comp[19] \$353 VDD pfet_03v3 L=0.28U W=16.5U AS=5.577P AD=5.577P
+ PS=23.18U PD=23.18U
M$506 VDD comp[20] \$353 VDD pfet_03v3 L=0.28U W=16.5U AS=5.577P AD=5.577P
+ PS=23.18U PD=23.18U
M$511 VDD \$350 \$353 VDD pfet_03v3 L=0.28U W=16.5U AS=5.577P AD=5.577P
+ PS=23.18U PD=23.18U
M$516 VDD comp[21] \$350 VDD pfet_03v3 L=0.28U W=16.5U AS=5.577P AD=5.577P
+ PS=23.18U PD=23.18U
M$521 VDD \$353 OUT|wl[20] VDD pfet_03v3 L=0.28U W=16.5U AS=5.577P AD=5.577P
+ PS=23.18U PD=23.18U
M$526 VDD comp[20] \$365 VDD pfet_03v3 L=0.28U W=16.5U AS=5.577P AD=5.577P
+ PS=23.18U PD=23.18U
M$531 VDD comp[21] \$365 VDD pfet_03v3 L=0.28U W=16.5U AS=5.577P AD=5.577P
+ PS=23.18U PD=23.18U
M$536 VDD \$366 \$365 VDD pfet_03v3 L=0.28U W=16.5U AS=5.577P AD=5.577P
+ PS=23.18U PD=23.18U
M$541 VDD comp[22] \$366 VDD pfet_03v3 L=0.28U W=16.5U AS=5.577P AD=5.577P
+ PS=23.18U PD=23.18U
M$546 VDD \$365 OUT|wl[21] VDD pfet_03v3 L=0.28U W=16.5U AS=5.577P AD=5.577P
+ PS=23.18U PD=23.18U
M$551 VDD comp[21] \$387 VDD pfet_03v3 L=0.28U W=16.5U AS=5.577P AD=5.577P
+ PS=23.18U PD=23.18U
M$556 VDD comp[22] \$387 VDD pfet_03v3 L=0.28U W=16.5U AS=5.577P AD=5.577P
+ PS=23.18U PD=23.18U
M$561 VDD \$384 \$387 VDD pfet_03v3 L=0.28U W=16.5U AS=5.577P AD=5.577P
+ PS=23.18U PD=23.18U
M$566 VDD comp[23] \$384 VDD pfet_03v3 L=0.28U W=16.5U AS=5.577P AD=5.577P
+ PS=23.18U PD=23.18U
M$571 VDD \$387 OUT|wl[22] VDD pfet_03v3 L=0.28U W=16.5U AS=5.577P AD=5.577P
+ PS=23.18U PD=23.18U
M$576 VDD comp[22] \$399 VDD pfet_03v3 L=0.28U W=16.5U AS=5.577P AD=5.577P
+ PS=23.18U PD=23.18U
M$581 VDD comp[23] \$399 VDD pfet_03v3 L=0.28U W=16.5U AS=5.577P AD=5.577P
+ PS=23.18U PD=23.18U
M$586 VDD \$400 \$399 VDD pfet_03v3 L=0.28U W=16.5U AS=5.577P AD=5.577P
+ PS=23.18U PD=23.18U
M$591 VDD comp[24] \$400 VDD pfet_03v3 L=0.28U W=16.5U AS=5.577P AD=5.577P
+ PS=23.18U PD=23.18U
M$596 VDD \$399 OUT|wl[23] VDD pfet_03v3 L=0.28U W=16.5U AS=5.577P AD=5.577P
+ PS=23.18U PD=23.18U
M$601 VDD comp[23] \$421 VDD pfet_03v3 L=0.28U W=16.5U AS=5.577P AD=5.577P
+ PS=23.18U PD=23.18U
M$606 VDD comp[24] \$421 VDD pfet_03v3 L=0.28U W=16.5U AS=5.577P AD=5.577P
+ PS=23.18U PD=23.18U
M$611 VDD \$418 \$421 VDD pfet_03v3 L=0.28U W=16.5U AS=5.577P AD=5.577P
+ PS=23.18U PD=23.18U
M$616 VDD comp[25] \$418 VDD pfet_03v3 L=0.28U W=16.5U AS=5.577P AD=5.577P
+ PS=23.18U PD=23.18U
M$621 VDD \$421 OUT|wl[24] VDD pfet_03v3 L=0.28U W=16.5U AS=5.577P AD=5.577P
+ PS=23.18U PD=23.18U
M$626 VDD comp[24] \$433 VDD pfet_03v3 L=0.28U W=16.5U AS=5.577P AD=5.577P
+ PS=23.18U PD=23.18U
M$631 VDD comp[25] \$433 VDD pfet_03v3 L=0.28U W=16.5U AS=5.577P AD=5.577P
+ PS=23.18U PD=23.18U
M$636 VDD \$434 \$433 VDD pfet_03v3 L=0.28U W=16.5U AS=5.577P AD=5.577P
+ PS=23.18U PD=23.18U
M$641 VDD comp[26] \$434 VDD pfet_03v3 L=0.28U W=16.5U AS=5.577P AD=5.577P
+ PS=23.18U PD=23.18U
M$646 VDD \$433 OUT|wl[25] VDD pfet_03v3 L=0.28U W=16.5U AS=5.577P AD=5.577P
+ PS=23.18U PD=23.18U
M$651 VDD comp[25] \$455 VDD pfet_03v3 L=0.28U W=16.5U AS=5.577P AD=5.577P
+ PS=23.18U PD=23.18U
M$656 VDD comp[26] \$455 VDD pfet_03v3 L=0.28U W=16.5U AS=5.577P AD=5.577P
+ PS=23.18U PD=23.18U
M$661 VDD \$452 \$455 VDD pfet_03v3 L=0.28U W=16.5U AS=5.577P AD=5.577P
+ PS=23.18U PD=23.18U
M$666 VDD comp[27] \$452 VDD pfet_03v3 L=0.28U W=16.5U AS=5.577P AD=5.577P
+ PS=23.18U PD=23.18U
M$671 VDD \$455 OUT|wl[26] VDD pfet_03v3 L=0.28U W=16.5U AS=5.577P AD=5.577P
+ PS=23.18U PD=23.18U
M$676 VDD comp[26] \$467 VDD pfet_03v3 L=0.28U W=16.5U AS=5.577P AD=5.577P
+ PS=23.18U PD=23.18U
M$681 VDD comp[27] \$467 VDD pfet_03v3 L=0.28U W=16.5U AS=5.577P AD=5.577P
+ PS=23.18U PD=23.18U
M$686 VDD \$468 \$467 VDD pfet_03v3 L=0.28U W=16.5U AS=5.577P AD=5.577P
+ PS=23.18U PD=23.18U
M$691 VDD comp[28] \$468 VDD pfet_03v3 L=0.28U W=16.5U AS=5.577P AD=5.577P
+ PS=23.18U PD=23.18U
M$696 VDD \$467 OUT|wl[27] VDD pfet_03v3 L=0.28U W=16.5U AS=5.577P AD=5.577P
+ PS=23.18U PD=23.18U
M$701 VDD comp[27] \$489 VDD pfet_03v3 L=0.28U W=16.5U AS=5.577P AD=5.577P
+ PS=23.18U PD=23.18U
M$706 VDD comp[28] \$489 VDD pfet_03v3 L=0.28U W=16.5U AS=5.577P AD=5.577P
+ PS=23.18U PD=23.18U
M$711 VDD \$486 \$489 VDD pfet_03v3 L=0.28U W=16.5U AS=5.577P AD=5.577P
+ PS=23.18U PD=23.18U
M$716 VDD comp[29] \$486 VDD pfet_03v3 L=0.28U W=16.5U AS=5.577P AD=5.577P
+ PS=23.18U PD=23.18U
M$721 VDD \$489 OUT|wl[28] VDD pfet_03v3 L=0.28U W=16.5U AS=5.577P AD=5.577P
+ PS=23.18U PD=23.18U
M$726 VDD comp[28] \$501 VDD pfet_03v3 L=0.28U W=16.5U AS=5.577P AD=5.577P
+ PS=23.18U PD=23.18U
M$731 VDD comp[29] \$501 VDD pfet_03v3 L=0.28U W=16.5U AS=5.577P AD=5.577P
+ PS=23.18U PD=23.18U
M$736 VDD \$502 \$501 VDD pfet_03v3 L=0.28U W=16.5U AS=5.577P AD=5.577P
+ PS=23.18U PD=23.18U
M$741 VDD comp[30] \$502 VDD pfet_03v3 L=0.28U W=16.5U AS=5.577P AD=5.577P
+ PS=23.18U PD=23.18U
M$746 VDD \$501 OUT|wl[29] VDD pfet_03v3 L=0.28U W=16.5U AS=5.577P AD=5.577P
+ PS=23.18U PD=23.18U
M$751 VDD comp[29] \$523 VDD pfet_03v3 L=0.28U W=16.5U AS=5.577P AD=5.577P
+ PS=23.18U PD=23.18U
M$756 VDD comp[30] \$523 VDD pfet_03v3 L=0.28U W=16.5U AS=5.577P AD=5.577P
+ PS=23.18U PD=23.18U
M$761 VDD \$520 \$523 VDD pfet_03v3 L=0.28U W=16.5U AS=5.577P AD=5.577P
+ PS=23.18U PD=23.18U
M$766 VDD comp[31] \$520 VDD pfet_03v3 L=0.28U W=16.5U AS=5.577P AD=5.577P
+ PS=23.18U PD=23.18U
M$771 VDD \$523 OUT|wl[30] VDD pfet_03v3 L=0.28U W=16.5U AS=5.577P AD=5.577P
+ PS=23.18U PD=23.18U
M$776 VDD comp[30] \$535 VDD pfet_03v3 L=0.28U W=16.5U AS=5.577P AD=5.577P
+ PS=23.18U PD=23.18U
M$781 VDD comp[31] \$535 VDD pfet_03v3 L=0.28U W=16.5U AS=5.577P AD=5.577P
+ PS=23.18U PD=23.18U
M$786 VDD \$536 \$535 VDD pfet_03v3 L=0.28U W=16.5U AS=5.577P AD=5.577P
+ PS=23.18U PD=23.18U
M$791 VDD comp[32] \$536 VDD pfet_03v3 L=0.28U W=16.5U AS=5.577P AD=5.577P
+ PS=23.18U PD=23.18U
M$796 VDD \$535 OUT|wl[31] VDD pfet_03v3 L=0.28U W=16.5U AS=5.577P AD=5.577P
+ PS=23.18U PD=23.18U
M$801 VDD comp[31] \$557 VDD pfet_03v3 L=0.28U W=16.5U AS=5.577P AD=5.577P
+ PS=23.18U PD=23.18U
M$806 VDD comp[32] \$557 VDD pfet_03v3 L=0.28U W=16.5U AS=5.577P AD=5.577P
+ PS=23.18U PD=23.18U
M$811 VDD \$554 \$557 VDD pfet_03v3 L=0.28U W=16.5U AS=5.577P AD=5.577P
+ PS=23.18U PD=23.18U
M$816 VDD comp[33] \$554 VDD pfet_03v3 L=0.28U W=16.5U AS=5.577P AD=5.577P
+ PS=23.18U PD=23.18U
M$821 VDD \$557 OUT|wl[32] VDD pfet_03v3 L=0.28U W=16.5U AS=5.577P AD=5.577P
+ PS=23.18U PD=23.18U
M$826 VDD comp[32] \$569 VDD pfet_03v3 L=0.28U W=16.5U AS=5.577P AD=5.577P
+ PS=23.18U PD=23.18U
M$831 VDD comp[33] \$569 VDD pfet_03v3 L=0.28U W=16.5U AS=5.577P AD=5.577P
+ PS=23.18U PD=23.18U
M$836 VDD \$570 \$569 VDD pfet_03v3 L=0.28U W=16.5U AS=5.577P AD=5.577P
+ PS=23.18U PD=23.18U
M$841 VDD comp[34] \$570 VDD pfet_03v3 L=0.28U W=16.5U AS=5.577P AD=5.577P
+ PS=23.18U PD=23.18U
M$846 VDD \$569 OUT|wl[33] VDD pfet_03v3 L=0.28U W=16.5U AS=5.577P AD=5.577P
+ PS=23.18U PD=23.18U
M$851 VDD comp[33] \$591 VDD pfet_03v3 L=0.28U W=16.5U AS=5.577P AD=5.577P
+ PS=23.18U PD=23.18U
M$856 VDD comp[34] \$591 VDD pfet_03v3 L=0.28U W=16.5U AS=5.577P AD=5.577P
+ PS=23.18U PD=23.18U
M$861 VDD \$588 \$591 VDD pfet_03v3 L=0.28U W=16.5U AS=5.577P AD=5.577P
+ PS=23.18U PD=23.18U
M$866 VDD comp[35] \$588 VDD pfet_03v3 L=0.28U W=16.5U AS=5.577P AD=5.577P
+ PS=23.18U PD=23.18U
M$871 VDD \$591 OUT|wl[34] VDD pfet_03v3 L=0.28U W=16.5U AS=5.577P AD=5.577P
+ PS=23.18U PD=23.18U
M$876 VDD comp[34] \$603 VDD pfet_03v3 L=0.28U W=16.5U AS=5.577P AD=5.577P
+ PS=23.18U PD=23.18U
M$881 VDD comp[35] \$603 VDD pfet_03v3 L=0.28U W=16.5U AS=5.577P AD=5.577P
+ PS=23.18U PD=23.18U
M$886 VDD \$604 \$603 VDD pfet_03v3 L=0.28U W=16.5U AS=5.577P AD=5.577P
+ PS=23.18U PD=23.18U
M$891 VDD comp[36] \$604 VDD pfet_03v3 L=0.28U W=16.5U AS=5.577P AD=5.577P
+ PS=23.18U PD=23.18U
M$896 VDD \$603 OUT|wl[35] VDD pfet_03v3 L=0.28U W=16.5U AS=5.577P AD=5.577P
+ PS=23.18U PD=23.18U
M$901 VDD comp[35] \$625 VDD pfet_03v3 L=0.28U W=16.5U AS=5.577P AD=5.577P
+ PS=23.18U PD=23.18U
M$906 VDD comp[36] \$625 VDD pfet_03v3 L=0.28U W=16.5U AS=5.577P AD=5.577P
+ PS=23.18U PD=23.18U
M$911 VDD \$622 \$625 VDD pfet_03v3 L=0.28U W=16.5U AS=5.577P AD=5.577P
+ PS=23.18U PD=23.18U
M$916 VDD comp[37] \$622 VDD pfet_03v3 L=0.28U W=16.5U AS=5.577P AD=5.577P
+ PS=23.18U PD=23.18U
M$921 VDD \$625 OUT|wl[36] VDD pfet_03v3 L=0.28U W=16.5U AS=5.577P AD=5.577P
+ PS=23.18U PD=23.18U
M$926 VDD comp[36] \$637 VDD pfet_03v3 L=0.28U W=16.5U AS=5.577P AD=5.577P
+ PS=23.18U PD=23.18U
M$931 VDD comp[37] \$637 VDD pfet_03v3 L=0.28U W=16.5U AS=5.577P AD=5.577P
+ PS=23.18U PD=23.18U
M$936 VDD \$638 \$637 VDD pfet_03v3 L=0.28U W=16.5U AS=5.577P AD=5.577P
+ PS=23.18U PD=23.18U
M$941 VDD comp[38] \$638 VDD pfet_03v3 L=0.28U W=16.5U AS=5.577P AD=5.577P
+ PS=23.18U PD=23.18U
M$946 VDD \$637 OUT|wl[37] VDD pfet_03v3 L=0.28U W=16.5U AS=5.577P AD=5.577P
+ PS=23.18U PD=23.18U
M$951 VDD comp[37] \$659 VDD pfet_03v3 L=0.28U W=16.5U AS=5.577P AD=5.577P
+ PS=23.18U PD=23.18U
M$956 VDD comp[38] \$659 VDD pfet_03v3 L=0.28U W=16.5U AS=5.577P AD=5.577P
+ PS=23.18U PD=23.18U
M$961 VDD \$656 \$659 VDD pfet_03v3 L=0.28U W=16.5U AS=5.577P AD=5.577P
+ PS=23.18U PD=23.18U
M$966 VDD comp[39] \$656 VDD pfet_03v3 L=0.28U W=16.5U AS=5.577P AD=5.577P
+ PS=23.18U PD=23.18U
M$971 VDD \$659 OUT|wl[38] VDD pfet_03v3 L=0.28U W=16.5U AS=5.577P AD=5.577P
+ PS=23.18U PD=23.18U
M$976 VDD comp[38] \$671 VDD pfet_03v3 L=0.28U W=16.5U AS=5.577P AD=5.577P
+ PS=23.18U PD=23.18U
M$981 VDD comp[39] \$671 VDD pfet_03v3 L=0.28U W=16.5U AS=5.577P AD=5.577P
+ PS=23.18U PD=23.18U
M$986 VDD \$672 \$671 VDD pfet_03v3 L=0.28U W=16.5U AS=5.577P AD=5.577P
+ PS=23.18U PD=23.18U
M$991 VDD comp[40] \$672 VDD pfet_03v3 L=0.28U W=16.5U AS=5.577P AD=5.577P
+ PS=23.18U PD=23.18U
M$996 VDD \$671 OUT|wl[39] VDD pfet_03v3 L=0.28U W=16.5U AS=5.577P AD=5.577P
+ PS=23.18U PD=23.18U
M$1001 VDD comp[39] \$693 VDD pfet_03v3 L=0.28U W=16.5U AS=5.577P AD=5.577P
+ PS=23.18U PD=23.18U
M$1006 VDD comp[40] \$693 VDD pfet_03v3 L=0.28U W=16.5U AS=5.577P AD=5.577P
+ PS=23.18U PD=23.18U
M$1011 VDD \$690 \$693 VDD pfet_03v3 L=0.28U W=16.5U AS=5.577P AD=5.577P
+ PS=23.18U PD=23.18U
M$1016 VDD comp[41] \$690 VDD pfet_03v3 L=0.28U W=16.5U AS=5.577P AD=5.577P
+ PS=23.18U PD=23.18U
M$1021 VDD \$693 OUT|wl[40] VDD pfet_03v3 L=0.28U W=16.5U AS=5.577P AD=5.577P
+ PS=23.18U PD=23.18U
M$1026 VDD comp[40] \$705 VDD pfet_03v3 L=0.28U W=16.5U AS=5.577P AD=5.577P
+ PS=23.18U PD=23.18U
M$1031 VDD comp[41] \$705 VDD pfet_03v3 L=0.28U W=16.5U AS=5.577P AD=5.577P
+ PS=23.18U PD=23.18U
M$1036 VDD \$706 \$705 VDD pfet_03v3 L=0.28U W=16.5U AS=5.577P AD=5.577P
+ PS=23.18U PD=23.18U
M$1041 VDD comp[42] \$706 VDD pfet_03v3 L=0.28U W=16.5U AS=5.577P AD=5.577P
+ PS=23.18U PD=23.18U
M$1046 VDD \$705 OUT|wl[41] VDD pfet_03v3 L=0.28U W=16.5U AS=5.577P AD=5.577P
+ PS=23.18U PD=23.18U
M$1051 VDD comp[41] \$727 VDD pfet_03v3 L=0.28U W=16.5U AS=5.577P AD=5.577P
+ PS=23.18U PD=23.18U
M$1056 VDD comp[42] \$727 VDD pfet_03v3 L=0.28U W=16.5U AS=5.577P AD=5.577P
+ PS=23.18U PD=23.18U
M$1061 VDD \$724 \$727 VDD pfet_03v3 L=0.28U W=16.5U AS=5.577P AD=5.577P
+ PS=23.18U PD=23.18U
M$1066 VDD comp[43] \$724 VDD pfet_03v3 L=0.28U W=16.5U AS=5.577P AD=5.577P
+ PS=23.18U PD=23.18U
M$1071 VDD \$727 OUT|wl[42] VDD pfet_03v3 L=0.28U W=16.5U AS=5.577P AD=5.577P
+ PS=23.18U PD=23.18U
M$1076 VDD comp[42] \$739 VDD pfet_03v3 L=0.28U W=16.5U AS=5.577P AD=5.577P
+ PS=23.18U PD=23.18U
M$1081 VDD comp[43] \$739 VDD pfet_03v3 L=0.28U W=16.5U AS=5.577P AD=5.577P
+ PS=23.18U PD=23.18U
M$1086 VDD \$740 \$739 VDD pfet_03v3 L=0.28U W=16.5U AS=5.577P AD=5.577P
+ PS=23.18U PD=23.18U
M$1091 VDD comp[44] \$740 VDD pfet_03v3 L=0.28U W=16.5U AS=5.577P AD=5.577P
+ PS=23.18U PD=23.18U
M$1096 VDD \$739 OUT|wl[43] VDD pfet_03v3 L=0.28U W=16.5U AS=5.577P AD=5.577P
+ PS=23.18U PD=23.18U
M$1101 VDD comp[43] \$761 VDD pfet_03v3 L=0.28U W=16.5U AS=5.577P AD=5.577P
+ PS=23.18U PD=23.18U
M$1106 VDD comp[44] \$761 VDD pfet_03v3 L=0.28U W=16.5U AS=5.577P AD=5.577P
+ PS=23.18U PD=23.18U
M$1111 VDD \$758 \$761 VDD pfet_03v3 L=0.28U W=16.5U AS=5.577P AD=5.577P
+ PS=23.18U PD=23.18U
M$1116 VDD comp[45] \$758 VDD pfet_03v3 L=0.28U W=16.5U AS=5.577P AD=5.577P
+ PS=23.18U PD=23.18U
M$1121 VDD \$761 OUT|wl[44] VDD pfet_03v3 L=0.28U W=16.5U AS=5.577P AD=5.577P
+ PS=23.18U PD=23.18U
M$1126 VDD comp[44] \$773 VDD pfet_03v3 L=0.28U W=16.5U AS=5.577P AD=5.577P
+ PS=23.18U PD=23.18U
M$1131 VDD comp[45] \$773 VDD pfet_03v3 L=0.28U W=16.5U AS=5.577P AD=5.577P
+ PS=23.18U PD=23.18U
M$1136 VDD \$774 \$773 VDD pfet_03v3 L=0.28U W=16.5U AS=5.577P AD=5.577P
+ PS=23.18U PD=23.18U
M$1141 VDD comp[46] \$774 VDD pfet_03v3 L=0.28U W=16.5U AS=5.577P AD=5.577P
+ PS=23.18U PD=23.18U
M$1146 VDD \$773 OUT|wl[45] VDD pfet_03v3 L=0.28U W=16.5U AS=5.577P AD=5.577P
+ PS=23.18U PD=23.18U
M$1151 VDD comp[45] \$795 VDD pfet_03v3 L=0.28U W=16.5U AS=5.577P AD=5.577P
+ PS=23.18U PD=23.18U
M$1156 VDD comp[46] \$795 VDD pfet_03v3 L=0.28U W=16.5U AS=5.577P AD=5.577P
+ PS=23.18U PD=23.18U
M$1161 VDD \$792 \$795 VDD pfet_03v3 L=0.28U W=16.5U AS=5.577P AD=5.577P
+ PS=23.18U PD=23.18U
M$1166 VDD comp[47] \$792 VDD pfet_03v3 L=0.28U W=16.5U AS=5.577P AD=5.577P
+ PS=23.18U PD=23.18U
M$1171 VDD \$795 OUT|wl[46] VDD pfet_03v3 L=0.28U W=16.5U AS=5.577P AD=5.577P
+ PS=23.18U PD=23.18U
M$1176 VDD comp[46] \$807 VDD pfet_03v3 L=0.28U W=16.5U AS=5.577P AD=5.577P
+ PS=23.18U PD=23.18U
M$1181 VDD comp[47] \$807 VDD pfet_03v3 L=0.28U W=16.5U AS=5.577P AD=5.577P
+ PS=23.18U PD=23.18U
M$1186 VDD \$808 \$807 VDD pfet_03v3 L=0.28U W=16.5U AS=5.577P AD=5.577P
+ PS=23.18U PD=23.18U
M$1191 VDD comp[48] \$808 VDD pfet_03v3 L=0.28U W=16.5U AS=5.577P AD=5.577P
+ PS=23.18U PD=23.18U
M$1196 VDD \$807 OUT|wl[47] VDD pfet_03v3 L=0.28U W=16.5U AS=5.577P AD=5.577P
+ PS=23.18U PD=23.18U
M$1201 VDD comp[47] \$829 VDD pfet_03v3 L=0.28U W=16.5U AS=5.577P AD=5.577P
+ PS=23.18U PD=23.18U
M$1206 VDD comp[48] \$829 VDD pfet_03v3 L=0.28U W=16.5U AS=5.577P AD=5.577P
+ PS=23.18U PD=23.18U
M$1211 VDD \$826 \$829 VDD pfet_03v3 L=0.28U W=16.5U AS=5.577P AD=5.577P
+ PS=23.18U PD=23.18U
M$1216 VDD comp[49] \$826 VDD pfet_03v3 L=0.28U W=16.5U AS=5.577P AD=5.577P
+ PS=23.18U PD=23.18U
M$1221 VDD \$829 OUT|wl[48] VDD pfet_03v3 L=0.28U W=16.5U AS=5.577P AD=5.577P
+ PS=23.18U PD=23.18U
M$1226 VDD comp[48] \$841 VDD pfet_03v3 L=0.28U W=16.5U AS=5.577P AD=5.577P
+ PS=23.18U PD=23.18U
M$1231 VDD comp[49] \$841 VDD pfet_03v3 L=0.28U W=16.5U AS=5.577P AD=5.577P
+ PS=23.18U PD=23.18U
M$1236 VDD \$842 \$841 VDD pfet_03v3 L=0.28U W=16.5U AS=5.577P AD=5.577P
+ PS=23.18U PD=23.18U
M$1241 VDD comp[50] \$842 VDD pfet_03v3 L=0.28U W=16.5U AS=5.577P AD=5.577P
+ PS=23.18U PD=23.18U
M$1246 VDD \$841 OUT|wl[49] VDD pfet_03v3 L=0.28U W=16.5U AS=5.577P AD=5.577P
+ PS=23.18U PD=23.18U
M$1251 VDD comp[49] \$863 VDD pfet_03v3 L=0.28U W=16.5U AS=5.577P AD=5.577P
+ PS=23.18U PD=23.18U
M$1256 VDD comp[50] \$863 VDD pfet_03v3 L=0.28U W=16.5U AS=5.577P AD=5.577P
+ PS=23.18U PD=23.18U
M$1261 VDD \$860 \$863 VDD pfet_03v3 L=0.28U W=16.5U AS=5.577P AD=5.577P
+ PS=23.18U PD=23.18U
M$1266 VDD comp[51] \$860 VDD pfet_03v3 L=0.28U W=16.5U AS=5.577P AD=5.577P
+ PS=23.18U PD=23.18U
M$1271 VDD \$863 OUT|wl[50] VDD pfet_03v3 L=0.28U W=16.5U AS=5.577P AD=5.577P
+ PS=23.18U PD=23.18U
M$1276 VDD comp[50] \$875 VDD pfet_03v3 L=0.28U W=16.5U AS=5.577P AD=5.577P
+ PS=23.18U PD=23.18U
M$1281 VDD comp[51] \$875 VDD pfet_03v3 L=0.28U W=16.5U AS=5.577P AD=5.577P
+ PS=23.18U PD=23.18U
M$1286 VDD \$876 \$875 VDD pfet_03v3 L=0.28U W=16.5U AS=5.577P AD=5.577P
+ PS=23.18U PD=23.18U
M$1291 VDD comp[52] \$876 VDD pfet_03v3 L=0.28U W=16.5U AS=5.577P AD=5.577P
+ PS=23.18U PD=23.18U
M$1296 VDD \$875 OUT|wl[51] VDD pfet_03v3 L=0.28U W=16.5U AS=5.577P AD=5.577P
+ PS=23.18U PD=23.18U
M$1301 VDD comp[51] \$897 VDD pfet_03v3 L=0.28U W=16.5U AS=5.577P AD=5.577P
+ PS=23.18U PD=23.18U
M$1306 VDD comp[52] \$897 VDD pfet_03v3 L=0.28U W=16.5U AS=5.577P AD=5.577P
+ PS=23.18U PD=23.18U
M$1311 VDD \$894 \$897 VDD pfet_03v3 L=0.28U W=16.5U AS=5.577P AD=5.577P
+ PS=23.18U PD=23.18U
M$1316 VDD comp[53] \$894 VDD pfet_03v3 L=0.28U W=16.5U AS=5.577P AD=5.577P
+ PS=23.18U PD=23.18U
M$1321 VDD \$897 OUT|wl[52] VDD pfet_03v3 L=0.28U W=16.5U AS=5.577P AD=5.577P
+ PS=23.18U PD=23.18U
M$1326 VDD comp[52] \$909 VDD pfet_03v3 L=0.28U W=16.5U AS=5.577P AD=5.577P
+ PS=23.18U PD=23.18U
M$1331 VDD comp[53] \$909 VDD pfet_03v3 L=0.28U W=16.5U AS=5.577P AD=5.577P
+ PS=23.18U PD=23.18U
M$1336 VDD \$910 \$909 VDD pfet_03v3 L=0.28U W=16.5U AS=5.577P AD=5.577P
+ PS=23.18U PD=23.18U
M$1341 VDD comp[54] \$910 VDD pfet_03v3 L=0.28U W=16.5U AS=5.577P AD=5.577P
+ PS=23.18U PD=23.18U
M$1346 VDD \$909 OUT|wl[53] VDD pfet_03v3 L=0.28U W=16.5U AS=5.577P AD=5.577P
+ PS=23.18U PD=23.18U
M$1351 VDD comp[53] \$931 VDD pfet_03v3 L=0.28U W=16.5U AS=5.577P AD=5.577P
+ PS=23.18U PD=23.18U
M$1356 VDD comp[54] \$931 VDD pfet_03v3 L=0.28U W=16.5U AS=5.577P AD=5.577P
+ PS=23.18U PD=23.18U
M$1361 VDD \$928 \$931 VDD pfet_03v3 L=0.28U W=16.5U AS=5.577P AD=5.577P
+ PS=23.18U PD=23.18U
M$1366 VDD comp[55] \$928 VDD pfet_03v3 L=0.28U W=16.5U AS=5.577P AD=5.577P
+ PS=23.18U PD=23.18U
M$1371 VDD \$931 OUT|wl[54] VDD pfet_03v3 L=0.28U W=16.5U AS=5.577P AD=5.577P
+ PS=23.18U PD=23.18U
M$1376 VDD comp[54] \$943 VDD pfet_03v3 L=0.28U W=16.5U AS=5.577P AD=5.577P
+ PS=23.18U PD=23.18U
M$1381 VDD comp[55] \$943 VDD pfet_03v3 L=0.28U W=16.5U AS=5.577P AD=5.577P
+ PS=23.18U PD=23.18U
M$1386 VDD \$944 \$943 VDD pfet_03v3 L=0.28U W=16.5U AS=5.577P AD=5.577P
+ PS=23.18U PD=23.18U
M$1391 VDD comp[56] \$944 VDD pfet_03v3 L=0.28U W=16.5U AS=5.577P AD=5.577P
+ PS=23.18U PD=23.18U
M$1396 VDD \$943 OUT|wl[55] VDD pfet_03v3 L=0.28U W=16.5U AS=5.577P AD=5.577P
+ PS=23.18U PD=23.18U
M$1401 VDD comp[55] \$965 VDD pfet_03v3 L=0.28U W=16.5U AS=5.577P AD=5.577P
+ PS=23.18U PD=23.18U
M$1406 VDD comp[56] \$965 VDD pfet_03v3 L=0.28U W=16.5U AS=5.577P AD=5.577P
+ PS=23.18U PD=23.18U
M$1411 VDD \$962 \$965 VDD pfet_03v3 L=0.28U W=16.5U AS=5.577P AD=5.577P
+ PS=23.18U PD=23.18U
M$1416 VDD comp[57] \$962 VDD pfet_03v3 L=0.28U W=16.5U AS=5.577P AD=5.577P
+ PS=23.18U PD=23.18U
M$1421 VDD \$965 OUT|wl[56] VDD pfet_03v3 L=0.28U W=16.5U AS=5.577P AD=5.577P
+ PS=23.18U PD=23.18U
M$1426 VDD comp[56] \$977 VDD pfet_03v3 L=0.28U W=16.5U AS=5.577P AD=5.577P
+ PS=23.18U PD=23.18U
M$1431 VDD comp[57] \$977 VDD pfet_03v3 L=0.28U W=16.5U AS=5.577P AD=5.577P
+ PS=23.18U PD=23.18U
M$1436 VDD \$978 \$977 VDD pfet_03v3 L=0.28U W=16.5U AS=5.577P AD=5.577P
+ PS=23.18U PD=23.18U
M$1441 VDD comp[58] \$978 VDD pfet_03v3 L=0.28U W=16.5U AS=5.577P AD=5.577P
+ PS=23.18U PD=23.18U
M$1446 VDD \$977 OUT|wl[57] VDD pfet_03v3 L=0.28U W=16.5U AS=5.577P AD=5.577P
+ PS=23.18U PD=23.18U
M$1451 VDD comp[57] \$999 VDD pfet_03v3 L=0.28U W=16.5U AS=5.577P AD=5.577P
+ PS=23.18U PD=23.18U
M$1456 VDD comp[58] \$999 VDD pfet_03v3 L=0.28U W=16.5U AS=5.577P AD=5.577P
+ PS=23.18U PD=23.18U
M$1461 VDD \$996 \$999 VDD pfet_03v3 L=0.28U W=16.5U AS=5.577P AD=5.577P
+ PS=23.18U PD=23.18U
M$1466 VDD comp[59] \$996 VDD pfet_03v3 L=0.28U W=16.5U AS=5.577P AD=5.577P
+ PS=23.18U PD=23.18U
M$1471 VDD \$999 OUT|wl[58] VDD pfet_03v3 L=0.28U W=16.5U AS=5.577P AD=5.577P
+ PS=23.18U PD=23.18U
M$1476 VDD comp[58] \$1011 VDD pfet_03v3 L=0.28U W=16.5U AS=5.577P AD=5.577P
+ PS=23.18U PD=23.18U
M$1481 VDD comp[59] \$1011 VDD pfet_03v3 L=0.28U W=16.5U AS=5.577P AD=5.577P
+ PS=23.18U PD=23.18U
M$1486 VDD \$1012 \$1011 VDD pfet_03v3 L=0.28U W=16.5U AS=5.577P AD=5.577P
+ PS=23.18U PD=23.18U
M$1491 VDD comp[60] \$1012 VDD pfet_03v3 L=0.28U W=16.5U AS=5.577P AD=5.577P
+ PS=23.18U PD=23.18U
M$1496 VDD \$1011 OUT|wl[59] VDD pfet_03v3 L=0.28U W=16.5U AS=5.577P AD=5.577P
+ PS=23.18U PD=23.18U
M$1501 VDD comp[59] \$1033 VDD pfet_03v3 L=0.28U W=16.5U AS=5.577P AD=5.577P
+ PS=23.18U PD=23.18U
M$1506 VDD comp[60] \$1033 VDD pfet_03v3 L=0.28U W=16.5U AS=5.577P AD=5.577P
+ PS=23.18U PD=23.18U
M$1511 VDD \$1030 \$1033 VDD pfet_03v3 L=0.28U W=16.5U AS=5.577P AD=5.577P
+ PS=23.18U PD=23.18U
M$1516 VDD comp[61] \$1030 VDD pfet_03v3 L=0.28U W=16.5U AS=5.577P AD=5.577P
+ PS=23.18U PD=23.18U
M$1521 VDD \$1033 OUT|wl[60] VDD pfet_03v3 L=0.28U W=16.5U AS=5.577P AD=5.577P
+ PS=23.18U PD=23.18U
M$1526 VDD comp[60] \$1045 VDD pfet_03v3 L=0.28U W=16.5U AS=5.577P AD=5.577P
+ PS=23.18U PD=23.18U
M$1531 VDD comp[61] \$1045 VDD pfet_03v3 L=0.28U W=16.5U AS=5.577P AD=5.577P
+ PS=23.18U PD=23.18U
M$1536 VDD \$1046 \$1045 VDD pfet_03v3 L=0.28U W=16.5U AS=5.577P AD=5.577P
+ PS=23.18U PD=23.18U
M$1541 VDD comp[62] \$1046 VDD pfet_03v3 L=0.28U W=16.5U AS=5.577P AD=5.577P
+ PS=23.18U PD=23.18U
M$1546 VDD \$1045 OUT|wl[61] VDD pfet_03v3 L=0.28U W=16.5U AS=5.577P AD=5.577P
+ PS=23.18U PD=23.18U
M$1551 VDD comp[61] \$1067 VDD pfet_03v3 L=0.28U W=16.5U AS=5.577P AD=5.577P
+ PS=23.18U PD=23.18U
M$1556 VDD comp[62] \$1067 VDD pfet_03v3 L=0.28U W=16.5U AS=5.577P AD=5.577P
+ PS=23.18U PD=23.18U
M$1561 VDD \$1064 \$1067 VDD pfet_03v3 L=0.28U W=16.5U AS=5.577P AD=5.577P
+ PS=23.18U PD=23.18U
M$1566 VDD GND \$1064 VDD pfet_03v3 L=0.28U W=16.5U AS=5.577P AD=5.577P
+ PS=23.18U PD=23.18U
M$1571 VDD \$1067 OUT|wl[62] VDD pfet_03v3 L=0.28U W=16.5U AS=5.577P AD=5.577P
+ PS=23.18U PD=23.18U
M$1576 \$5 VDD \$1 GND nfet_03v3 L=0.28U W=10.16U AS=3.5306P AD=3.5306P
+ PS=15.48U PD=15.48U
M$1580 \$1 \$8 \$2 GND nfet_03v3 L=0.28U W=10.16U AS=3.5306P AD=3.5306P
+ PS=15.48U PD=15.48U
M$1584 \$2 \$10 GND GND nfet_03v3 L=0.28U W=10.16U AS=3.5306P AD=3.5306P
+ PS=15.48U PD=15.48U
M$1588 \$10 comp[1] GND GND nfet_03v3 L=0.28U W=10.16U AS=3.5306P AD=3.5306P
+ PS=15.48U PD=15.48U
M$1592 OUT|wl[0] \$5 GND GND nfet_03v3 L=0.28U W=10.16U AS=3.5306P AD=3.5306P
+ PS=15.48U PD=15.48U
M$1596 \$24 \$8 \$34 GND nfet_03v3 L=0.28U W=10.16U AS=3.5306P AD=3.5306P
+ PS=15.48U PD=15.48U
M$1600 \$34 comp[1] \$35 GND nfet_03v3 L=0.28U W=10.16U AS=3.5306P AD=3.5306P
+ PS=15.48U PD=15.48U
M$1604 \$35 \$25 GND GND nfet_03v3 L=0.28U W=10.16U AS=3.5306P AD=3.5306P
+ PS=15.48U PD=15.48U
M$1608 \$25 A_3|comp[2] GND GND nfet_03v3 L=0.28U W=10.16U AS=3.5306P
+ AD=3.5306P PS=15.48U PD=15.48U
M$1612 OUT|wl[1] \$24 GND GND nfet_03v3 L=0.28U W=10.16U AS=3.5306P AD=3.5306P
+ PS=15.48U PD=15.48U
M$1616 \$47 comp[1] \$37 GND nfet_03v3 L=0.28U W=10.16U AS=3.5306P AD=3.5306P
+ PS=15.48U PD=15.48U
M$1620 \$37 A_3|comp[2] \$38 GND nfet_03v3 L=0.28U W=10.16U AS=3.5306P
+ AD=3.5306P PS=15.48U PD=15.48U
M$1624 \$38 \$44 GND GND nfet_03v3 L=0.28U W=10.16U AS=3.5306P AD=3.5306P
+ PS=15.48U PD=15.48U
M$1628 \$44 A_4|B_3|comp[3] GND GND nfet_03v3 L=0.28U W=10.16U AS=3.5306P
+ AD=3.5306P PS=15.48U PD=15.48U
M$1632 OUT|wl[2] \$47 GND GND nfet_03v3 L=0.28U W=10.16U AS=3.5306P AD=3.5306P
+ PS=15.48U PD=15.48U
M$1636 \$59 A_3|comp[2] \$69 GND nfet_03v3 L=0.28U W=10.16U AS=3.5306P
+ AD=3.5306P PS=15.48U PD=15.48U
M$1640 \$69 A_4|B_3|comp[3] \$70 GND nfet_03v3 L=0.28U W=10.16U AS=3.5306P
+ AD=3.5306P PS=15.48U PD=15.48U
M$1644 \$70 \$60 GND GND nfet_03v3 L=0.28U W=10.16U AS=3.5306P AD=3.5306P
+ PS=15.48U PD=15.48U
M$1648 \$60 A_5|B_4|C_3|comp[4] GND GND nfet_03v3 L=0.28U W=10.16U AS=3.5306P
+ AD=3.5306P PS=15.48U PD=15.48U
M$1652 OUT|wl[3] \$59 GND GND nfet_03v3 L=0.28U W=10.16U AS=3.5306P AD=3.5306P
+ PS=15.48U PD=15.48U
M$1656 \$81 A_4|B_3|comp[3] \$71 GND nfet_03v3 L=0.28U W=10.16U AS=3.5306P
+ AD=3.5306P PS=15.48U PD=15.48U
M$1660 \$71 A_5|B_4|C_3|comp[4] \$72 GND nfet_03v3 L=0.28U W=10.16U AS=3.5306P
+ AD=3.5306P PS=15.48U PD=15.48U
M$1664 \$72 \$78 GND GND nfet_03v3 L=0.28U W=10.16U AS=3.5306P AD=3.5306P
+ PS=15.48U PD=15.48U
M$1668 \$78 A_6|B_5|C_4|comp[5] GND GND nfet_03v3 L=0.28U W=10.16U AS=3.5306P
+ AD=3.5306P PS=15.48U PD=15.48U
M$1672 OUT|wl[4] \$81 GND GND nfet_03v3 L=0.28U W=10.16U AS=3.5306P AD=3.5306P
+ PS=15.48U PD=15.48U
M$1676 \$93 A_5|B_4|C_3|comp[4] \$103 GND nfet_03v3 L=0.28U W=10.16U AS=3.5306P
+ AD=3.5306P PS=15.48U PD=15.48U
M$1680 \$103 A_6|B_5|C_4|comp[5] \$104 GND nfet_03v3 L=0.28U W=10.16U
+ AS=3.5306P AD=3.5306P PS=15.48U PD=15.48U
M$1684 \$104 \$94 GND GND nfet_03v3 L=0.28U W=10.16U AS=3.5306P AD=3.5306P
+ PS=15.48U PD=15.48U
M$1688 \$94 B_6|C_5|comp[6] GND GND nfet_03v3 L=0.28U W=10.16U AS=3.5306P
+ AD=3.5306P PS=15.48U PD=15.48U
M$1692 OUT|wl[5] \$93 GND GND nfet_03v3 L=0.28U W=10.16U AS=3.5306P AD=3.5306P
+ PS=15.48U PD=15.48U
M$1696 \$115 A_6|B_5|C_4|comp[5] \$105 GND nfet_03v3 L=0.28U W=10.16U
+ AS=3.5306P AD=3.5306P PS=15.48U PD=15.48U
M$1700 \$105 B_6|C_5|comp[6] \$106 GND nfet_03v3 L=0.28U W=10.16U AS=3.5306P
+ AD=3.5306P PS=15.48U PD=15.48U
M$1704 \$106 \$112 GND GND nfet_03v3 L=0.28U W=10.16U AS=3.5306P AD=3.5306P
+ PS=15.48U PD=15.48U
M$1708 \$112 C_6|comp[7] GND GND nfet_03v3 L=0.28U W=10.16U AS=3.5306P
+ AD=3.5306P PS=15.48U PD=15.48U
M$1712 OUT|wl[6] \$115 GND GND nfet_03v3 L=0.28U W=10.16U AS=3.5306P AD=3.5306P
+ PS=15.48U PD=15.48U
M$1716 \$127 B_6|C_5|comp[6] \$137 GND nfet_03v3 L=0.28U W=10.16U AS=3.5306P
+ AD=3.5306P PS=15.48U PD=15.48U
M$1720 \$137 C_6|comp[7] \$138 GND nfet_03v3 L=0.28U W=10.16U AS=3.5306P
+ AD=3.5306P PS=15.48U PD=15.48U
M$1724 \$138 \$128 GND GND nfet_03v3 L=0.28U W=10.16U AS=3.5306P AD=3.5306P
+ PS=15.48U PD=15.48U
M$1728 \$128 comp[8] GND GND nfet_03v3 L=0.28U W=10.16U AS=3.5306P AD=3.5306P
+ PS=15.48U PD=15.48U
M$1732 OUT|wl[7] \$127 GND GND nfet_03v3 L=0.28U W=10.16U AS=3.5306P AD=3.5306P
+ PS=15.48U PD=15.48U
M$1736 \$149 C_6|comp[7] \$139 GND nfet_03v3 L=0.28U W=10.16U AS=3.5306P
+ AD=3.5306P PS=15.48U PD=15.48U
M$1740 \$139 comp[8] \$140 GND nfet_03v3 L=0.28U W=10.16U AS=3.5306P AD=3.5306P
+ PS=15.48U PD=15.48U
M$1744 \$140 \$146 GND GND nfet_03v3 L=0.28U W=10.16U AS=3.5306P AD=3.5306P
+ PS=15.48U PD=15.48U
M$1748 \$146 comp[9] GND GND nfet_03v3 L=0.28U W=10.16U AS=3.5306P AD=3.5306P
+ PS=15.48U PD=15.48U
M$1752 OUT|wl[8] \$149 GND GND nfet_03v3 L=0.28U W=10.16U AS=3.5306P AD=3.5306P
+ PS=15.48U PD=15.48U
M$1756 \$161 comp[8] \$171 GND nfet_03v3 L=0.28U W=10.16U AS=3.5306P AD=3.5306P
+ PS=15.48U PD=15.48U
M$1760 \$171 comp[9] \$172 GND nfet_03v3 L=0.28U W=10.16U AS=3.5306P AD=3.5306P
+ PS=15.48U PD=15.48U
M$1764 \$172 \$162 GND GND nfet_03v3 L=0.28U W=10.16U AS=3.5306P AD=3.5306P
+ PS=15.48U PD=15.48U
M$1768 \$162 comp[10] GND GND nfet_03v3 L=0.28U W=10.16U AS=3.5306P AD=3.5306P
+ PS=15.48U PD=15.48U
M$1772 OUT|wl[9] \$161 GND GND nfet_03v3 L=0.28U W=10.16U AS=3.5306P AD=3.5306P
+ PS=15.48U PD=15.48U
M$1776 \$183 comp[9] \$173 GND nfet_03v3 L=0.28U W=10.16U AS=3.5306P AD=3.5306P
+ PS=15.48U PD=15.48U
M$1780 \$173 comp[10] \$174 GND nfet_03v3 L=0.28U W=10.16U AS=3.5306P
+ AD=3.5306P PS=15.48U PD=15.48U
M$1784 \$174 \$180 GND GND nfet_03v3 L=0.28U W=10.16U AS=3.5306P AD=3.5306P
+ PS=15.48U PD=15.48U
M$1788 \$180 comp[11] GND GND nfet_03v3 L=0.28U W=10.16U AS=3.5306P AD=3.5306P
+ PS=15.48U PD=15.48U
M$1792 OUT|wl[10] \$183 GND GND nfet_03v3 L=0.28U W=10.16U AS=3.5306P
+ AD=3.5306P PS=15.48U PD=15.48U
M$1796 \$195 comp[10] \$205 GND nfet_03v3 L=0.28U W=10.16U AS=3.5306P
+ AD=3.5306P PS=15.48U PD=15.48U
M$1800 \$205 comp[11] \$206 GND nfet_03v3 L=0.28U W=10.16U AS=3.5306P
+ AD=3.5306P PS=15.48U PD=15.48U
M$1804 \$206 \$196 GND GND nfet_03v3 L=0.28U W=10.16U AS=3.5306P AD=3.5306P
+ PS=15.48U PD=15.48U
M$1808 \$196 comp[12] GND GND nfet_03v3 L=0.28U W=10.16U AS=3.5306P AD=3.5306P
+ PS=15.48U PD=15.48U
M$1812 OUT|wl[11] \$195 GND GND nfet_03v3 L=0.28U W=10.16U AS=3.5306P
+ AD=3.5306P PS=15.48U PD=15.48U
M$1816 \$217 comp[11] \$207 GND nfet_03v3 L=0.28U W=10.16U AS=3.5306P
+ AD=3.5306P PS=15.48U PD=15.48U
M$1820 \$207 comp[12] \$208 GND nfet_03v3 L=0.28U W=10.16U AS=3.5306P
+ AD=3.5306P PS=15.48U PD=15.48U
M$1824 \$208 \$214 GND GND nfet_03v3 L=0.28U W=10.16U AS=3.5306P AD=3.5306P
+ PS=15.48U PD=15.48U
M$1828 \$214 comp[13] GND GND nfet_03v3 L=0.28U W=10.16U AS=3.5306P AD=3.5306P
+ PS=15.48U PD=15.48U
M$1832 OUT|wl[12] \$217 GND GND nfet_03v3 L=0.28U W=10.16U AS=3.5306P
+ AD=3.5306P PS=15.48U PD=15.48U
M$1836 \$229 comp[12] \$239 GND nfet_03v3 L=0.28U W=10.16U AS=3.5306P
+ AD=3.5306P PS=15.48U PD=15.48U
M$1840 \$239 comp[13] \$240 GND nfet_03v3 L=0.28U W=10.16U AS=3.5306P
+ AD=3.5306P PS=15.48U PD=15.48U
M$1844 \$240 \$230 GND GND nfet_03v3 L=0.28U W=10.16U AS=3.5306P AD=3.5306P
+ PS=15.48U PD=15.48U
M$1848 \$230 VDD|comp[14] GND GND nfet_03v3 L=0.28U W=10.16U AS=3.5306P
+ AD=3.5306P PS=15.48U PD=15.48U
M$1852 OUT|wl[13] \$229 GND GND nfet_03v3 L=0.28U W=10.16U AS=3.5306P
+ AD=3.5306P PS=15.48U PD=15.48U
M$1856 \$251 comp[13] \$241 GND nfet_03v3 L=0.28U W=10.16U AS=3.5306P
+ AD=3.5306P PS=15.48U PD=15.48U
M$1860 \$241 VDD|comp[14] \$242 GND nfet_03v3 L=0.28U W=10.16U AS=3.5306P
+ AD=3.5306P PS=15.48U PD=15.48U
M$1864 \$242 \$248 GND GND nfet_03v3 L=0.28U W=10.16U AS=3.5306P AD=3.5306P
+ PS=15.48U PD=15.48U
M$1868 \$248 comp[15] GND GND nfet_03v3 L=0.28U W=10.16U AS=3.5306P AD=3.5306P
+ PS=15.48U PD=15.48U
M$1872 OUT|wl[14] \$251 GND GND nfet_03v3 L=0.28U W=10.16U AS=3.5306P
+ AD=3.5306P PS=15.48U PD=15.48U
M$1876 \$263 VDD|comp[14] \$273 GND nfet_03v3 L=0.28U W=10.16U AS=3.5306P
+ AD=3.5306P PS=15.48U PD=15.48U
M$1880 \$273 comp[15] \$274 GND nfet_03v3 L=0.28U W=10.16U AS=3.5306P
+ AD=3.5306P PS=15.48U PD=15.48U
M$1884 \$274 \$264 GND GND nfet_03v3 L=0.28U W=10.16U AS=3.5306P AD=3.5306P
+ PS=15.48U PD=15.48U
M$1888 \$264 comp[16] GND GND nfet_03v3 L=0.28U W=10.16U AS=3.5306P AD=3.5306P
+ PS=15.48U PD=15.48U
M$1892 OUT|wl[15] \$263 GND GND nfet_03v3 L=0.28U W=10.16U AS=3.5306P
+ AD=3.5306P PS=15.48U PD=15.48U
M$1896 \$285 comp[15] \$275 GND nfet_03v3 L=0.28U W=10.16U AS=3.5306P
+ AD=3.5306P PS=15.48U PD=15.48U
M$1900 \$275 comp[16] \$276 GND nfet_03v3 L=0.28U W=10.16U AS=3.5306P
+ AD=3.5306P PS=15.48U PD=15.48U
M$1904 \$276 \$282 GND GND nfet_03v3 L=0.28U W=10.16U AS=3.5306P AD=3.5306P
+ PS=15.48U PD=15.48U
M$1908 \$282 comp[17] GND GND nfet_03v3 L=0.28U W=10.16U AS=3.5306P AD=3.5306P
+ PS=15.48U PD=15.48U
M$1912 OUT|wl[16] \$285 GND GND nfet_03v3 L=0.28U W=10.16U AS=3.5306P
+ AD=3.5306P PS=15.48U PD=15.48U
M$1916 \$297 comp[16] \$307 GND nfet_03v3 L=0.28U W=10.16U AS=3.5306P
+ AD=3.5306P PS=15.48U PD=15.48U
M$1920 \$307 comp[17] \$308 GND nfet_03v3 L=0.28U W=10.16U AS=3.5306P
+ AD=3.5306P PS=15.48U PD=15.48U
M$1924 \$308 \$298 GND GND nfet_03v3 L=0.28U W=10.16U AS=3.5306P AD=3.5306P
+ PS=15.48U PD=15.48U
M$1928 \$298 comp[18] GND GND nfet_03v3 L=0.28U W=10.16U AS=3.5306P AD=3.5306P
+ PS=15.48U PD=15.48U
M$1932 OUT|wl[17] \$297 GND GND nfet_03v3 L=0.28U W=10.16U AS=3.5306P
+ AD=3.5306P PS=15.48U PD=15.48U
M$1936 \$319 comp[17] \$309 GND nfet_03v3 L=0.28U W=10.16U AS=3.5306P
+ AD=3.5306P PS=15.48U PD=15.48U
M$1940 \$309 comp[18] \$310 GND nfet_03v3 L=0.28U W=10.16U AS=3.5306P
+ AD=3.5306P PS=15.48U PD=15.48U
M$1944 \$310 \$316 GND GND nfet_03v3 L=0.28U W=10.16U AS=3.5306P AD=3.5306P
+ PS=15.48U PD=15.48U
M$1948 \$316 comp[19] GND GND nfet_03v3 L=0.28U W=10.16U AS=3.5306P AD=3.5306P
+ PS=15.48U PD=15.48U
M$1952 OUT|wl[18] \$319 GND GND nfet_03v3 L=0.28U W=10.16U AS=3.5306P
+ AD=3.5306P PS=15.48U PD=15.48U
M$1956 \$331 comp[18] \$341 GND nfet_03v3 L=0.28U W=10.16U AS=3.5306P
+ AD=3.5306P PS=15.48U PD=15.48U
M$1960 \$341 comp[19] \$342 GND nfet_03v3 L=0.28U W=10.16U AS=3.5306P
+ AD=3.5306P PS=15.48U PD=15.48U
M$1964 \$342 \$332 GND GND nfet_03v3 L=0.28U W=10.16U AS=3.5306P AD=3.5306P
+ PS=15.48U PD=15.48U
M$1968 \$332 comp[20] GND GND nfet_03v3 L=0.28U W=10.16U AS=3.5306P AD=3.5306P
+ PS=15.48U PD=15.48U
M$1972 OUT|wl[19] \$331 GND GND nfet_03v3 L=0.28U W=10.16U AS=3.5306P
+ AD=3.5306P PS=15.48U PD=15.48U
M$1976 \$353 comp[19] \$343 GND nfet_03v3 L=0.28U W=10.16U AS=3.5306P
+ AD=3.5306P PS=15.48U PD=15.48U
M$1980 \$343 comp[20] \$344 GND nfet_03v3 L=0.28U W=10.16U AS=3.5306P
+ AD=3.5306P PS=15.48U PD=15.48U
M$1984 \$344 \$350 GND GND nfet_03v3 L=0.28U W=10.16U AS=3.5306P AD=3.5306P
+ PS=15.48U PD=15.48U
M$1988 \$350 comp[21] GND GND nfet_03v3 L=0.28U W=10.16U AS=3.5306P AD=3.5306P
+ PS=15.48U PD=15.48U
M$1992 OUT|wl[20] \$353 GND GND nfet_03v3 L=0.28U W=10.16U AS=3.5306P
+ AD=3.5306P PS=15.48U PD=15.48U
M$1996 \$365 comp[20] \$375 GND nfet_03v3 L=0.28U W=10.16U AS=3.5306P
+ AD=3.5306P PS=15.48U PD=15.48U
M$2000 \$375 comp[21] \$376 GND nfet_03v3 L=0.28U W=10.16U AS=3.5306P
+ AD=3.5306P PS=15.48U PD=15.48U
M$2004 \$376 \$366 GND GND nfet_03v3 L=0.28U W=10.16U AS=3.5306P AD=3.5306P
+ PS=15.48U PD=15.48U
M$2008 \$366 comp[22] GND GND nfet_03v3 L=0.28U W=10.16U AS=3.5306P AD=3.5306P
+ PS=15.48U PD=15.48U
M$2012 OUT|wl[21] \$365 GND GND nfet_03v3 L=0.28U W=10.16U AS=3.5306P
+ AD=3.5306P PS=15.48U PD=15.48U
M$2016 \$387 comp[21] \$377 GND nfet_03v3 L=0.28U W=10.16U AS=3.5306P
+ AD=3.5306P PS=15.48U PD=15.48U
M$2020 \$377 comp[22] \$378 GND nfet_03v3 L=0.28U W=10.16U AS=3.5306P
+ AD=3.5306P PS=15.48U PD=15.48U
M$2024 \$378 \$384 GND GND nfet_03v3 L=0.28U W=10.16U AS=3.5306P AD=3.5306P
+ PS=15.48U PD=15.48U
M$2028 \$384 comp[23] GND GND nfet_03v3 L=0.28U W=10.16U AS=3.5306P AD=3.5306P
+ PS=15.48U PD=15.48U
M$2032 OUT|wl[22] \$387 GND GND nfet_03v3 L=0.28U W=10.16U AS=3.5306P
+ AD=3.5306P PS=15.48U PD=15.48U
M$2036 \$399 comp[22] \$409 GND nfet_03v3 L=0.28U W=10.16U AS=3.5306P
+ AD=3.5306P PS=15.48U PD=15.48U
M$2040 \$409 comp[23] \$410 GND nfet_03v3 L=0.28U W=10.16U AS=3.5306P
+ AD=3.5306P PS=15.48U PD=15.48U
M$2044 \$410 \$400 GND GND nfet_03v3 L=0.28U W=10.16U AS=3.5306P AD=3.5306P
+ PS=15.48U PD=15.48U
M$2048 \$400 comp[24] GND GND nfet_03v3 L=0.28U W=10.16U AS=3.5306P AD=3.5306P
+ PS=15.48U PD=15.48U
M$2052 OUT|wl[23] \$399 GND GND nfet_03v3 L=0.28U W=10.16U AS=3.5306P
+ AD=3.5306P PS=15.48U PD=15.48U
M$2056 \$421 comp[23] \$411 GND nfet_03v3 L=0.28U W=10.16U AS=3.5306P
+ AD=3.5306P PS=15.48U PD=15.48U
M$2060 \$411 comp[24] \$412 GND nfet_03v3 L=0.28U W=10.16U AS=3.5306P
+ AD=3.5306P PS=15.48U PD=15.48U
M$2064 \$412 \$418 GND GND nfet_03v3 L=0.28U W=10.16U AS=3.5306P AD=3.5306P
+ PS=15.48U PD=15.48U
M$2068 \$418 comp[25] GND GND nfet_03v3 L=0.28U W=10.16U AS=3.5306P AD=3.5306P
+ PS=15.48U PD=15.48U
M$2072 OUT|wl[24] \$421 GND GND nfet_03v3 L=0.28U W=10.16U AS=3.5306P
+ AD=3.5306P PS=15.48U PD=15.48U
M$2076 \$433 comp[24] \$443 GND nfet_03v3 L=0.28U W=10.16U AS=3.5306P
+ AD=3.5306P PS=15.48U PD=15.48U
M$2080 \$443 comp[25] \$444 GND nfet_03v3 L=0.28U W=10.16U AS=3.5306P
+ AD=3.5306P PS=15.48U PD=15.48U
M$2084 \$444 \$434 GND GND nfet_03v3 L=0.28U W=10.16U AS=3.5306P AD=3.5306P
+ PS=15.48U PD=15.48U
M$2088 \$434 comp[26] GND GND nfet_03v3 L=0.28U W=10.16U AS=3.5306P AD=3.5306P
+ PS=15.48U PD=15.48U
M$2092 OUT|wl[25] \$433 GND GND nfet_03v3 L=0.28U W=10.16U AS=3.5306P
+ AD=3.5306P PS=15.48U PD=15.48U
M$2096 \$455 comp[25] \$445 GND nfet_03v3 L=0.28U W=10.16U AS=3.5306P
+ AD=3.5306P PS=15.48U PD=15.48U
M$2100 \$445 comp[26] \$446 GND nfet_03v3 L=0.28U W=10.16U AS=3.5306P
+ AD=3.5306P PS=15.48U PD=15.48U
M$2104 \$446 \$452 GND GND nfet_03v3 L=0.28U W=10.16U AS=3.5306P AD=3.5306P
+ PS=15.48U PD=15.48U
M$2108 \$452 comp[27] GND GND nfet_03v3 L=0.28U W=10.16U AS=3.5306P AD=3.5306P
+ PS=15.48U PD=15.48U
M$2112 OUT|wl[26] \$455 GND GND nfet_03v3 L=0.28U W=10.16U AS=3.5306P
+ AD=3.5306P PS=15.48U PD=15.48U
M$2116 \$467 comp[26] \$477 GND nfet_03v3 L=0.28U W=10.16U AS=3.5306P
+ AD=3.5306P PS=15.48U PD=15.48U
M$2120 \$477 comp[27] \$478 GND nfet_03v3 L=0.28U W=10.16U AS=3.5306P
+ AD=3.5306P PS=15.48U PD=15.48U
M$2124 \$478 \$468 GND GND nfet_03v3 L=0.28U W=10.16U AS=3.5306P AD=3.5306P
+ PS=15.48U PD=15.48U
M$2128 \$468 comp[28] GND GND nfet_03v3 L=0.28U W=10.16U AS=3.5306P AD=3.5306P
+ PS=15.48U PD=15.48U
M$2132 OUT|wl[27] \$467 GND GND nfet_03v3 L=0.28U W=10.16U AS=3.5306P
+ AD=3.5306P PS=15.48U PD=15.48U
M$2136 \$489 comp[27] \$479 GND nfet_03v3 L=0.28U W=10.16U AS=3.5306P
+ AD=3.5306P PS=15.48U PD=15.48U
M$2140 \$479 comp[28] \$480 GND nfet_03v3 L=0.28U W=10.16U AS=3.5306P
+ AD=3.5306P PS=15.48U PD=15.48U
M$2144 \$480 \$486 GND GND nfet_03v3 L=0.28U W=10.16U AS=3.5306P AD=3.5306P
+ PS=15.48U PD=15.48U
M$2148 \$486 comp[29] GND GND nfet_03v3 L=0.28U W=10.16U AS=3.5306P AD=3.5306P
+ PS=15.48U PD=15.48U
M$2152 OUT|wl[28] \$489 GND GND nfet_03v3 L=0.28U W=10.16U AS=3.5306P
+ AD=3.5306P PS=15.48U PD=15.48U
M$2156 \$501 comp[28] \$511 GND nfet_03v3 L=0.28U W=10.16U AS=3.5306P
+ AD=3.5306P PS=15.48U PD=15.48U
M$2160 \$511 comp[29] \$512 GND nfet_03v3 L=0.28U W=10.16U AS=3.5306P
+ AD=3.5306P PS=15.48U PD=15.48U
M$2164 \$512 \$502 GND GND nfet_03v3 L=0.28U W=10.16U AS=3.5306P AD=3.5306P
+ PS=15.48U PD=15.48U
M$2168 \$502 comp[30] GND GND nfet_03v3 L=0.28U W=10.16U AS=3.5306P AD=3.5306P
+ PS=15.48U PD=15.48U
M$2172 OUT|wl[29] \$501 GND GND nfet_03v3 L=0.28U W=10.16U AS=3.5306P
+ AD=3.5306P PS=15.48U PD=15.48U
M$2176 \$523 comp[29] \$513 GND nfet_03v3 L=0.28U W=10.16U AS=3.5306P
+ AD=3.5306P PS=15.48U PD=15.48U
M$2180 \$513 comp[30] \$514 GND nfet_03v3 L=0.28U W=10.16U AS=3.5306P
+ AD=3.5306P PS=15.48U PD=15.48U
M$2184 \$514 \$520 GND GND nfet_03v3 L=0.28U W=10.16U AS=3.5306P AD=3.5306P
+ PS=15.48U PD=15.48U
M$2188 \$520 comp[31] GND GND nfet_03v3 L=0.28U W=10.16U AS=3.5306P AD=3.5306P
+ PS=15.48U PD=15.48U
M$2192 OUT|wl[30] \$523 GND GND nfet_03v3 L=0.28U W=10.16U AS=3.5306P
+ AD=3.5306P PS=15.48U PD=15.48U
M$2196 \$535 comp[30] \$545 GND nfet_03v3 L=0.28U W=10.16U AS=3.5306P
+ AD=3.5306P PS=15.48U PD=15.48U
M$2200 \$545 comp[31] \$546 GND nfet_03v3 L=0.28U W=10.16U AS=3.5306P
+ AD=3.5306P PS=15.48U PD=15.48U
M$2204 \$546 \$536 GND GND nfet_03v3 L=0.28U W=10.16U AS=3.5306P AD=3.5306P
+ PS=15.48U PD=15.48U
M$2208 \$536 comp[32] GND GND nfet_03v3 L=0.28U W=10.16U AS=3.5306P AD=3.5306P
+ PS=15.48U PD=15.48U
M$2212 OUT|wl[31] \$535 GND GND nfet_03v3 L=0.28U W=10.16U AS=3.5306P
+ AD=3.5306P PS=15.48U PD=15.48U
M$2216 \$557 comp[31] \$547 GND nfet_03v3 L=0.28U W=10.16U AS=3.5306P
+ AD=3.5306P PS=15.48U PD=15.48U
M$2220 \$547 comp[32] \$548 GND nfet_03v3 L=0.28U W=10.16U AS=3.5306P
+ AD=3.5306P PS=15.48U PD=15.48U
M$2224 \$548 \$554 GND GND nfet_03v3 L=0.28U W=10.16U AS=3.5306P AD=3.5306P
+ PS=15.48U PD=15.48U
M$2228 \$554 comp[33] GND GND nfet_03v3 L=0.28U W=10.16U AS=3.5306P AD=3.5306P
+ PS=15.48U PD=15.48U
M$2232 OUT|wl[32] \$557 GND GND nfet_03v3 L=0.28U W=10.16U AS=3.5306P
+ AD=3.5306P PS=15.48U PD=15.48U
M$2236 \$569 comp[32] \$579 GND nfet_03v3 L=0.28U W=10.16U AS=3.5306P
+ AD=3.5306P PS=15.48U PD=15.48U
M$2240 \$579 comp[33] \$580 GND nfet_03v3 L=0.28U W=10.16U AS=3.5306P
+ AD=3.5306P PS=15.48U PD=15.48U
M$2244 \$580 \$570 GND GND nfet_03v3 L=0.28U W=10.16U AS=3.5306P AD=3.5306P
+ PS=15.48U PD=15.48U
M$2248 \$570 comp[34] GND GND nfet_03v3 L=0.28U W=10.16U AS=3.5306P AD=3.5306P
+ PS=15.48U PD=15.48U
M$2252 OUT|wl[33] \$569 GND GND nfet_03v3 L=0.28U W=10.16U AS=3.5306P
+ AD=3.5306P PS=15.48U PD=15.48U
M$2256 \$591 comp[33] \$581 GND nfet_03v3 L=0.28U W=10.16U AS=3.5306P
+ AD=3.5306P PS=15.48U PD=15.48U
M$2260 \$581 comp[34] \$582 GND nfet_03v3 L=0.28U W=10.16U AS=3.5306P
+ AD=3.5306P PS=15.48U PD=15.48U
M$2264 \$582 \$588 GND GND nfet_03v3 L=0.28U W=10.16U AS=3.5306P AD=3.5306P
+ PS=15.48U PD=15.48U
M$2268 \$588 comp[35] GND GND nfet_03v3 L=0.28U W=10.16U AS=3.5306P AD=3.5306P
+ PS=15.48U PD=15.48U
M$2272 OUT|wl[34] \$591 GND GND nfet_03v3 L=0.28U W=10.16U AS=3.5306P
+ AD=3.5306P PS=15.48U PD=15.48U
M$2276 \$603 comp[34] \$613 GND nfet_03v3 L=0.28U W=10.16U AS=3.5306P
+ AD=3.5306P PS=15.48U PD=15.48U
M$2280 \$613 comp[35] \$614 GND nfet_03v3 L=0.28U W=10.16U AS=3.5306P
+ AD=3.5306P PS=15.48U PD=15.48U
M$2284 \$614 \$604 GND GND nfet_03v3 L=0.28U W=10.16U AS=3.5306P AD=3.5306P
+ PS=15.48U PD=15.48U
M$2288 \$604 comp[36] GND GND nfet_03v3 L=0.28U W=10.16U AS=3.5306P AD=3.5306P
+ PS=15.48U PD=15.48U
M$2292 OUT|wl[35] \$603 GND GND nfet_03v3 L=0.28U W=10.16U AS=3.5306P
+ AD=3.5306P PS=15.48U PD=15.48U
M$2296 \$625 comp[35] \$615 GND nfet_03v3 L=0.28U W=10.16U AS=3.5306P
+ AD=3.5306P PS=15.48U PD=15.48U
M$2300 \$615 comp[36] \$616 GND nfet_03v3 L=0.28U W=10.16U AS=3.5306P
+ AD=3.5306P PS=15.48U PD=15.48U
M$2304 \$616 \$622 GND GND nfet_03v3 L=0.28U W=10.16U AS=3.5306P AD=3.5306P
+ PS=15.48U PD=15.48U
M$2308 \$622 comp[37] GND GND nfet_03v3 L=0.28U W=10.16U AS=3.5306P AD=3.5306P
+ PS=15.48U PD=15.48U
M$2312 OUT|wl[36] \$625 GND GND nfet_03v3 L=0.28U W=10.16U AS=3.5306P
+ AD=3.5306P PS=15.48U PD=15.48U
M$2316 \$637 comp[36] \$647 GND nfet_03v3 L=0.28U W=10.16U AS=3.5306P
+ AD=3.5306P PS=15.48U PD=15.48U
M$2320 \$647 comp[37] \$648 GND nfet_03v3 L=0.28U W=10.16U AS=3.5306P
+ AD=3.5306P PS=15.48U PD=15.48U
M$2324 \$648 \$638 GND GND nfet_03v3 L=0.28U W=10.16U AS=3.5306P AD=3.5306P
+ PS=15.48U PD=15.48U
M$2328 \$638 comp[38] GND GND nfet_03v3 L=0.28U W=10.16U AS=3.5306P AD=3.5306P
+ PS=15.48U PD=15.48U
M$2332 OUT|wl[37] \$637 GND GND nfet_03v3 L=0.28U W=10.16U AS=3.5306P
+ AD=3.5306P PS=15.48U PD=15.48U
M$2336 \$659 comp[37] \$649 GND nfet_03v3 L=0.28U W=10.16U AS=3.5306P
+ AD=3.5306P PS=15.48U PD=15.48U
M$2340 \$649 comp[38] \$650 GND nfet_03v3 L=0.28U W=10.16U AS=3.5306P
+ AD=3.5306P PS=15.48U PD=15.48U
M$2344 \$650 \$656 GND GND nfet_03v3 L=0.28U W=10.16U AS=3.5306P AD=3.5306P
+ PS=15.48U PD=15.48U
M$2348 \$656 comp[39] GND GND nfet_03v3 L=0.28U W=10.16U AS=3.5306P AD=3.5306P
+ PS=15.48U PD=15.48U
M$2352 OUT|wl[38] \$659 GND GND nfet_03v3 L=0.28U W=10.16U AS=3.5306P
+ AD=3.5306P PS=15.48U PD=15.48U
M$2356 \$671 comp[38] \$681 GND nfet_03v3 L=0.28U W=10.16U AS=3.5306P
+ AD=3.5306P PS=15.48U PD=15.48U
M$2360 \$681 comp[39] \$682 GND nfet_03v3 L=0.28U W=10.16U AS=3.5306P
+ AD=3.5306P PS=15.48U PD=15.48U
M$2364 \$682 \$672 GND GND nfet_03v3 L=0.28U W=10.16U AS=3.5306P AD=3.5306P
+ PS=15.48U PD=15.48U
M$2368 \$672 comp[40] GND GND nfet_03v3 L=0.28U W=10.16U AS=3.5306P AD=3.5306P
+ PS=15.48U PD=15.48U
M$2372 OUT|wl[39] \$671 GND GND nfet_03v3 L=0.28U W=10.16U AS=3.5306P
+ AD=3.5306P PS=15.48U PD=15.48U
M$2376 \$693 comp[39] \$683 GND nfet_03v3 L=0.28U W=10.16U AS=3.5306P
+ AD=3.5306P PS=15.48U PD=15.48U
M$2380 \$683 comp[40] \$684 GND nfet_03v3 L=0.28U W=10.16U AS=3.5306P
+ AD=3.5306P PS=15.48U PD=15.48U
M$2384 \$684 \$690 GND GND nfet_03v3 L=0.28U W=10.16U AS=3.5306P AD=3.5306P
+ PS=15.48U PD=15.48U
M$2388 \$690 comp[41] GND GND nfet_03v3 L=0.28U W=10.16U AS=3.5306P AD=3.5306P
+ PS=15.48U PD=15.48U
M$2392 OUT|wl[40] \$693 GND GND nfet_03v3 L=0.28U W=10.16U AS=3.5306P
+ AD=3.5306P PS=15.48U PD=15.48U
M$2396 \$705 comp[40] \$715 GND nfet_03v3 L=0.28U W=10.16U AS=3.5306P
+ AD=3.5306P PS=15.48U PD=15.48U
M$2400 \$715 comp[41] \$716 GND nfet_03v3 L=0.28U W=10.16U AS=3.5306P
+ AD=3.5306P PS=15.48U PD=15.48U
M$2404 \$716 \$706 GND GND nfet_03v3 L=0.28U W=10.16U AS=3.5306P AD=3.5306P
+ PS=15.48U PD=15.48U
M$2408 \$706 comp[42] GND GND nfet_03v3 L=0.28U W=10.16U AS=3.5306P AD=3.5306P
+ PS=15.48U PD=15.48U
M$2412 OUT|wl[41] \$705 GND GND nfet_03v3 L=0.28U W=10.16U AS=3.5306P
+ AD=3.5306P PS=15.48U PD=15.48U
M$2416 \$727 comp[41] \$717 GND nfet_03v3 L=0.28U W=10.16U AS=3.5306P
+ AD=3.5306P PS=15.48U PD=15.48U
M$2420 \$717 comp[42] \$718 GND nfet_03v3 L=0.28U W=10.16U AS=3.5306P
+ AD=3.5306P PS=15.48U PD=15.48U
M$2424 \$718 \$724 GND GND nfet_03v3 L=0.28U W=10.16U AS=3.5306P AD=3.5306P
+ PS=15.48U PD=15.48U
M$2428 \$724 comp[43] GND GND nfet_03v3 L=0.28U W=10.16U AS=3.5306P AD=3.5306P
+ PS=15.48U PD=15.48U
M$2432 OUT|wl[42] \$727 GND GND nfet_03v3 L=0.28U W=10.16U AS=3.5306P
+ AD=3.5306P PS=15.48U PD=15.48U
M$2436 \$739 comp[42] \$749 GND nfet_03v3 L=0.28U W=10.16U AS=3.5306P
+ AD=3.5306P PS=15.48U PD=15.48U
M$2440 \$749 comp[43] \$750 GND nfet_03v3 L=0.28U W=10.16U AS=3.5306P
+ AD=3.5306P PS=15.48U PD=15.48U
M$2444 \$750 \$740 GND GND nfet_03v3 L=0.28U W=10.16U AS=3.5306P AD=3.5306P
+ PS=15.48U PD=15.48U
M$2448 \$740 comp[44] GND GND nfet_03v3 L=0.28U W=10.16U AS=3.5306P AD=3.5306P
+ PS=15.48U PD=15.48U
M$2452 OUT|wl[43] \$739 GND GND nfet_03v3 L=0.28U W=10.16U AS=3.5306P
+ AD=3.5306P PS=15.48U PD=15.48U
M$2456 \$761 comp[43] \$751 GND nfet_03v3 L=0.28U W=10.16U AS=3.5306P
+ AD=3.5306P PS=15.48U PD=15.48U
M$2460 \$751 comp[44] \$752 GND nfet_03v3 L=0.28U W=10.16U AS=3.5306P
+ AD=3.5306P PS=15.48U PD=15.48U
M$2464 \$752 \$758 GND GND nfet_03v3 L=0.28U W=10.16U AS=3.5306P AD=3.5306P
+ PS=15.48U PD=15.48U
M$2468 \$758 comp[45] GND GND nfet_03v3 L=0.28U W=10.16U AS=3.5306P AD=3.5306P
+ PS=15.48U PD=15.48U
M$2472 OUT|wl[44] \$761 GND GND nfet_03v3 L=0.28U W=10.16U AS=3.5306P
+ AD=3.5306P PS=15.48U PD=15.48U
M$2476 \$773 comp[44] \$783 GND nfet_03v3 L=0.28U W=10.16U AS=3.5306P
+ AD=3.5306P PS=15.48U PD=15.48U
M$2480 \$783 comp[45] \$784 GND nfet_03v3 L=0.28U W=10.16U AS=3.5306P
+ AD=3.5306P PS=15.48U PD=15.48U
M$2484 \$784 \$774 GND GND nfet_03v3 L=0.28U W=10.16U AS=3.5306P AD=3.5306P
+ PS=15.48U PD=15.48U
M$2488 \$774 comp[46] GND GND nfet_03v3 L=0.28U W=10.16U AS=3.5306P AD=3.5306P
+ PS=15.48U PD=15.48U
M$2492 OUT|wl[45] \$773 GND GND nfet_03v3 L=0.28U W=10.16U AS=3.5306P
+ AD=3.5306P PS=15.48U PD=15.48U
M$2496 \$795 comp[45] \$785 GND nfet_03v3 L=0.28U W=10.16U AS=3.5306P
+ AD=3.5306P PS=15.48U PD=15.48U
M$2500 \$785 comp[46] \$786 GND nfet_03v3 L=0.28U W=10.16U AS=3.5306P
+ AD=3.5306P PS=15.48U PD=15.48U
M$2504 \$786 \$792 GND GND nfet_03v3 L=0.28U W=10.16U AS=3.5306P AD=3.5306P
+ PS=15.48U PD=15.48U
M$2508 \$792 comp[47] GND GND nfet_03v3 L=0.28U W=10.16U AS=3.5306P AD=3.5306P
+ PS=15.48U PD=15.48U
M$2512 OUT|wl[46] \$795 GND GND nfet_03v3 L=0.28U W=10.16U AS=3.5306P
+ AD=3.5306P PS=15.48U PD=15.48U
M$2516 \$807 comp[46] \$817 GND nfet_03v3 L=0.28U W=10.16U AS=3.5306P
+ AD=3.5306P PS=15.48U PD=15.48U
M$2520 \$817 comp[47] \$818 GND nfet_03v3 L=0.28U W=10.16U AS=3.5306P
+ AD=3.5306P PS=15.48U PD=15.48U
M$2524 \$818 \$808 GND GND nfet_03v3 L=0.28U W=10.16U AS=3.5306P AD=3.5306P
+ PS=15.48U PD=15.48U
M$2528 \$808 comp[48] GND GND nfet_03v3 L=0.28U W=10.16U AS=3.5306P AD=3.5306P
+ PS=15.48U PD=15.48U
M$2532 OUT|wl[47] \$807 GND GND nfet_03v3 L=0.28U W=10.16U AS=3.5306P
+ AD=3.5306P PS=15.48U PD=15.48U
M$2536 \$829 comp[47] \$819 GND nfet_03v3 L=0.28U W=10.16U AS=3.5306P
+ AD=3.5306P PS=15.48U PD=15.48U
M$2540 \$819 comp[48] \$820 GND nfet_03v3 L=0.28U W=10.16U AS=3.5306P
+ AD=3.5306P PS=15.48U PD=15.48U
M$2544 \$820 \$826 GND GND nfet_03v3 L=0.28U W=10.16U AS=3.5306P AD=3.5306P
+ PS=15.48U PD=15.48U
M$2548 \$826 comp[49] GND GND nfet_03v3 L=0.28U W=10.16U AS=3.5306P AD=3.5306P
+ PS=15.48U PD=15.48U
M$2552 OUT|wl[48] \$829 GND GND nfet_03v3 L=0.28U W=10.16U AS=3.5306P
+ AD=3.5306P PS=15.48U PD=15.48U
M$2556 \$841 comp[48] \$851 GND nfet_03v3 L=0.28U W=10.16U AS=3.5306P
+ AD=3.5306P PS=15.48U PD=15.48U
M$2560 \$851 comp[49] \$852 GND nfet_03v3 L=0.28U W=10.16U AS=3.5306P
+ AD=3.5306P PS=15.48U PD=15.48U
M$2564 \$852 \$842 GND GND nfet_03v3 L=0.28U W=10.16U AS=3.5306P AD=3.5306P
+ PS=15.48U PD=15.48U
M$2568 \$842 comp[50] GND GND nfet_03v3 L=0.28U W=10.16U AS=3.5306P AD=3.5306P
+ PS=15.48U PD=15.48U
M$2572 OUT|wl[49] \$841 GND GND nfet_03v3 L=0.28U W=10.16U AS=3.5306P
+ AD=3.5306P PS=15.48U PD=15.48U
M$2576 \$863 comp[49] \$853 GND nfet_03v3 L=0.28U W=10.16U AS=3.5306P
+ AD=3.5306P PS=15.48U PD=15.48U
M$2580 \$853 comp[50] \$854 GND nfet_03v3 L=0.28U W=10.16U AS=3.5306P
+ AD=3.5306P PS=15.48U PD=15.48U
M$2584 \$854 \$860 GND GND nfet_03v3 L=0.28U W=10.16U AS=3.5306P AD=3.5306P
+ PS=15.48U PD=15.48U
M$2588 \$860 comp[51] GND GND nfet_03v3 L=0.28U W=10.16U AS=3.5306P AD=3.5306P
+ PS=15.48U PD=15.48U
M$2592 OUT|wl[50] \$863 GND GND nfet_03v3 L=0.28U W=10.16U AS=3.5306P
+ AD=3.5306P PS=15.48U PD=15.48U
M$2596 \$875 comp[50] \$885 GND nfet_03v3 L=0.28U W=10.16U AS=3.5306P
+ AD=3.5306P PS=15.48U PD=15.48U
M$2600 \$885 comp[51] \$886 GND nfet_03v3 L=0.28U W=10.16U AS=3.5306P
+ AD=3.5306P PS=15.48U PD=15.48U
M$2604 \$886 \$876 GND GND nfet_03v3 L=0.28U W=10.16U AS=3.5306P AD=3.5306P
+ PS=15.48U PD=15.48U
M$2608 \$876 comp[52] GND GND nfet_03v3 L=0.28U W=10.16U AS=3.5306P AD=3.5306P
+ PS=15.48U PD=15.48U
M$2612 OUT|wl[51] \$875 GND GND nfet_03v3 L=0.28U W=10.16U AS=3.5306P
+ AD=3.5306P PS=15.48U PD=15.48U
M$2616 \$897 comp[51] \$887 GND nfet_03v3 L=0.28U W=10.16U AS=3.5306P
+ AD=3.5306P PS=15.48U PD=15.48U
M$2620 \$887 comp[52] \$888 GND nfet_03v3 L=0.28U W=10.16U AS=3.5306P
+ AD=3.5306P PS=15.48U PD=15.48U
M$2624 \$888 \$894 GND GND nfet_03v3 L=0.28U W=10.16U AS=3.5306P AD=3.5306P
+ PS=15.48U PD=15.48U
M$2628 \$894 comp[53] GND GND nfet_03v3 L=0.28U W=10.16U AS=3.5306P AD=3.5306P
+ PS=15.48U PD=15.48U
M$2632 OUT|wl[52] \$897 GND GND nfet_03v3 L=0.28U W=10.16U AS=3.5306P
+ AD=3.5306P PS=15.48U PD=15.48U
M$2636 \$909 comp[52] \$919 GND nfet_03v3 L=0.28U W=10.16U AS=3.5306P
+ AD=3.5306P PS=15.48U PD=15.48U
M$2640 \$919 comp[53] \$920 GND nfet_03v3 L=0.28U W=10.16U AS=3.5306P
+ AD=3.5306P PS=15.48U PD=15.48U
M$2644 \$920 \$910 GND GND nfet_03v3 L=0.28U W=10.16U AS=3.5306P AD=3.5306P
+ PS=15.48U PD=15.48U
M$2648 \$910 comp[54] GND GND nfet_03v3 L=0.28U W=10.16U AS=3.5306P AD=3.5306P
+ PS=15.48U PD=15.48U
M$2652 OUT|wl[53] \$909 GND GND nfet_03v3 L=0.28U W=10.16U AS=3.5306P
+ AD=3.5306P PS=15.48U PD=15.48U
M$2656 \$931 comp[53] \$921 GND nfet_03v3 L=0.28U W=10.16U AS=3.5306P
+ AD=3.5306P PS=15.48U PD=15.48U
M$2660 \$921 comp[54] \$922 GND nfet_03v3 L=0.28U W=10.16U AS=3.5306P
+ AD=3.5306P PS=15.48U PD=15.48U
M$2664 \$922 \$928 GND GND nfet_03v3 L=0.28U W=10.16U AS=3.5306P AD=3.5306P
+ PS=15.48U PD=15.48U
M$2668 \$928 comp[55] GND GND nfet_03v3 L=0.28U W=10.16U AS=3.5306P AD=3.5306P
+ PS=15.48U PD=15.48U
M$2672 OUT|wl[54] \$931 GND GND nfet_03v3 L=0.28U W=10.16U AS=3.5306P
+ AD=3.5306P PS=15.48U PD=15.48U
M$2676 \$943 comp[54] \$953 GND nfet_03v3 L=0.28U W=10.16U AS=3.5306P
+ AD=3.5306P PS=15.48U PD=15.48U
M$2680 \$953 comp[55] \$954 GND nfet_03v3 L=0.28U W=10.16U AS=3.5306P
+ AD=3.5306P PS=15.48U PD=15.48U
M$2684 \$954 \$944 GND GND nfet_03v3 L=0.28U W=10.16U AS=3.5306P AD=3.5306P
+ PS=15.48U PD=15.48U
M$2688 \$944 comp[56] GND GND nfet_03v3 L=0.28U W=10.16U AS=3.5306P AD=3.5306P
+ PS=15.48U PD=15.48U
M$2692 OUT|wl[55] \$943 GND GND nfet_03v3 L=0.28U W=10.16U AS=3.5306P
+ AD=3.5306P PS=15.48U PD=15.48U
M$2696 \$965 comp[55] \$955 GND nfet_03v3 L=0.28U W=10.16U AS=3.5306P
+ AD=3.5306P PS=15.48U PD=15.48U
M$2700 \$955 comp[56] \$956 GND nfet_03v3 L=0.28U W=10.16U AS=3.5306P
+ AD=3.5306P PS=15.48U PD=15.48U
M$2704 \$956 \$962 GND GND nfet_03v3 L=0.28U W=10.16U AS=3.5306P AD=3.5306P
+ PS=15.48U PD=15.48U
M$2708 \$962 comp[57] GND GND nfet_03v3 L=0.28U W=10.16U AS=3.5306P AD=3.5306P
+ PS=15.48U PD=15.48U
M$2712 OUT|wl[56] \$965 GND GND nfet_03v3 L=0.28U W=10.16U AS=3.5306P
+ AD=3.5306P PS=15.48U PD=15.48U
M$2716 \$977 comp[56] \$987 GND nfet_03v3 L=0.28U W=10.16U AS=3.5306P
+ AD=3.5306P PS=15.48U PD=15.48U
M$2720 \$987 comp[57] \$988 GND nfet_03v3 L=0.28U W=10.16U AS=3.5306P
+ AD=3.5306P PS=15.48U PD=15.48U
M$2724 \$988 \$978 GND GND nfet_03v3 L=0.28U W=10.16U AS=3.5306P AD=3.5306P
+ PS=15.48U PD=15.48U
M$2728 \$978 comp[58] GND GND nfet_03v3 L=0.28U W=10.16U AS=3.5306P AD=3.5306P
+ PS=15.48U PD=15.48U
M$2732 OUT|wl[57] \$977 GND GND nfet_03v3 L=0.28U W=10.16U AS=3.5306P
+ AD=3.5306P PS=15.48U PD=15.48U
M$2736 \$999 comp[57] \$989 GND nfet_03v3 L=0.28U W=10.16U AS=3.5306P
+ AD=3.5306P PS=15.48U PD=15.48U
M$2740 \$989 comp[58] \$990 GND nfet_03v3 L=0.28U W=10.16U AS=3.5306P
+ AD=3.5306P PS=15.48U PD=15.48U
M$2744 \$990 \$996 GND GND nfet_03v3 L=0.28U W=10.16U AS=3.5306P AD=3.5306P
+ PS=15.48U PD=15.48U
M$2748 \$996 comp[59] GND GND nfet_03v3 L=0.28U W=10.16U AS=3.5306P AD=3.5306P
+ PS=15.48U PD=15.48U
M$2752 OUT|wl[58] \$999 GND GND nfet_03v3 L=0.28U W=10.16U AS=3.5306P
+ AD=3.5306P PS=15.48U PD=15.48U
M$2756 \$1011 comp[58] \$1021 GND nfet_03v3 L=0.28U W=10.16U AS=3.5306P
+ AD=3.5306P PS=15.48U PD=15.48U
M$2760 \$1021 comp[59] \$1022 GND nfet_03v3 L=0.28U W=10.16U AS=3.5306P
+ AD=3.5306P PS=15.48U PD=15.48U
M$2764 \$1022 \$1012 GND GND nfet_03v3 L=0.28U W=10.16U AS=3.5306P AD=3.5306P
+ PS=15.48U PD=15.48U
M$2768 \$1012 comp[60] GND GND nfet_03v3 L=0.28U W=10.16U AS=3.5306P AD=3.5306P
+ PS=15.48U PD=15.48U
M$2772 OUT|wl[59] \$1011 GND GND nfet_03v3 L=0.28U W=10.16U AS=3.5306P
+ AD=3.5306P PS=15.48U PD=15.48U
M$2776 \$1033 comp[59] \$1023 GND nfet_03v3 L=0.28U W=10.16U AS=3.5306P
+ AD=3.5306P PS=15.48U PD=15.48U
M$2780 \$1023 comp[60] \$1024 GND nfet_03v3 L=0.28U W=10.16U AS=3.5306P
+ AD=3.5306P PS=15.48U PD=15.48U
M$2784 \$1024 \$1030 GND GND nfet_03v3 L=0.28U W=10.16U AS=3.5306P AD=3.5306P
+ PS=15.48U PD=15.48U
M$2788 \$1030 comp[61] GND GND nfet_03v3 L=0.28U W=10.16U AS=3.5306P AD=3.5306P
+ PS=15.48U PD=15.48U
M$2792 OUT|wl[60] \$1033 GND GND nfet_03v3 L=0.28U W=10.16U AS=3.5306P
+ AD=3.5306P PS=15.48U PD=15.48U
M$2796 \$1045 comp[60] \$1055 GND nfet_03v3 L=0.28U W=10.16U AS=3.5306P
+ AD=3.5306P PS=15.48U PD=15.48U
M$2800 \$1055 comp[61] \$1056 GND nfet_03v3 L=0.28U W=10.16U AS=3.5306P
+ AD=3.5306P PS=15.48U PD=15.48U
M$2804 \$1056 \$1046 GND GND nfet_03v3 L=0.28U W=10.16U AS=3.5306P AD=3.5306P
+ PS=15.48U PD=15.48U
M$2808 \$1046 comp[62] GND GND nfet_03v3 L=0.28U W=10.16U AS=3.5306P AD=3.5306P
+ PS=15.48U PD=15.48U
M$2812 OUT|wl[61] \$1045 GND GND nfet_03v3 L=0.28U W=10.16U AS=3.5306P
+ AD=3.5306P PS=15.48U PD=15.48U
M$2816 \$1067 comp[61] \$1057 GND nfet_03v3 L=0.28U W=10.16U AS=3.5306P
+ AD=3.5306P PS=15.48U PD=15.48U
M$2820 \$1057 comp[62] \$1058 GND nfet_03v3 L=0.28U W=10.16U AS=3.5306P
+ AD=3.5306P PS=15.48U PD=15.48U
M$2824 \$1058 \$1064 GND GND nfet_03v3 L=0.28U W=10.16U AS=3.5306P AD=3.5306P
+ PS=15.48U PD=15.48U
M$2828 \$1064 GND GND GND nfet_03v3 L=0.28U W=10.16U AS=3.5306P AD=3.5306P
+ PS=15.48U PD=15.48U
M$2832 OUT|wl[62] \$1067 GND GND nfet_03v3 L=0.28U W=10.16U AS=3.5306P
+ AD=3.5306P PS=15.48U PD=15.48U
.ENDS tm_to_bin2
