* NGSPICE file created from tm_to_bin2.ext - technology: gf180mcuD

.option scale=5n

.subckt pfet$2 a_28_n136# a_n92_0# a_94_0# w_n230_n138# VSUBS
X0 a_94_0# a_28_n136# a_n92_0# w_n230_n138# pfet_03v3 ad=52n pd=1.06m as=52n ps=1.06m w=400 l=56
C0 a_n92_0# w_n230_n138# 0.02009f
C1 a_28_n136# a_n92_0# 0.0115f
C2 a_94_0# a_n92_0# 0.09167f
C3 a_28_n136# w_n230_n138# 0.14368f
C4 a_94_0# w_n230_n138# 0.20387f
C5 a_28_n136# a_94_0# 0.0115f
C6 a_94_0# VSUBS 0.01994f
C7 a_n92_0# VSUBS 0.06093f
C8 a_28_n136# VSUBS 0.07992f
C9 w_n230_n138# VSUBS 1.54634f
.ends

.subckt nfet a_30_260# a_n84_0# a_94_0# VSUBS
X0 a_94_0# a_30_260# a_n84_0# VSUBS nfet_03v3 ad=24.4n pd=0.644m as=24.4n ps=0.644m w=200 l=56
C0 a_n84_0# a_94_0# 0.02606f
C1 a_94_0# VSUBS 0.04141f
C2 a_n84_0# VSUBS 0.04141f
C3 a_30_260# VSUBS 0.22065f
.ends

.subckt pfet$1 a_28_n136# w_n180_n88# a_n92_0# a_94_0# VSUBS
X0 a_94_0# a_28_n136# a_n92_0# w_n180_n88# pfet_03v3 ad=52n pd=1.06m as=52n ps=1.06m w=400 l=56
C0 a_n92_0# w_n180_n88# 0.0133f
C1 a_28_n136# a_n92_0# 0.0115f
C2 a_94_0# a_n92_0# 0.09167f
C3 a_28_n136# w_n180_n88# 0.09253f
C4 a_94_0# w_n180_n88# 0.0133f
C5 a_28_n136# a_94_0# 0.0115f
C6 a_94_0# VSUBS 0.06773f
C7 a_n92_0# VSUBS 0.06773f
C8 a_28_n136# VSUBS 0.13107f
C9 w_n180_n88# VSUBS 0.85018f
.ends

.subckt nfet$2 a_216_0# a_30_260# a_n84_0# a_94_0#
X0 a_94_0# a_30_260# a_n84_0# a_216_0# nfet_03v3 ad=24.4n pd=0.644m as=24.4n ps=0.644m w=200 l=56
C0 a_n84_0# a_94_0# 0.02606f
C1 a_94_0# a_216_0# 0.08353f
C2 a_n84_0# a_216_0# 0.04141f
C3 a_30_260# a_216_0# 0.22065f
.ends

.subckt NAND3 VDD B out m1_n11574_6541# m1_n10970_6203# m1_n11242_6204# m1_n11574_6940#
+ GND
Xpfet$2_0 m1_n10970_6203# out VDD VDD GND pfet$2
Xnfet_0 m1_n11242_6204# nfet_1/a_94_0# GND GND nfet
Xnfet_1 B nfet_2/a_94_0# nfet_1/a_94_0# GND nfet
Xnfet_2 m1_n11574_6541# m1_n10970_6203# nfet_2/a_94_0# GND nfet
Xnfet_3 m1_n11574_6940# GND m1_n11242_6204# GND nfet
Xpfet$1_0 m1_n11242_6204# VDD VDD m1_n10970_6203# GND pfet$1
Xpfet$1_1 B VDD m1_n10970_6203# VDD GND pfet$1
Xpfet$1_2 m1_n11574_6541# VDD VDD m1_n10970_6203# GND pfet$1
Xpfet$1_3 m1_n11574_6940# VDD VDD m1_n11242_6204# GND pfet$1
Xnfet$2_0 GND m1_n10970_6203# out GND nfet$2
C0 VDD out 0.10483f
C1 VDD m1_n11574_6541# 0.02761f
C2 B m1_n11242_6204# 0.5849f
C3 VDD m1_n11574_6940# 0.07445f
C4 out m1_n11242_6204# 0.03215f
C5 m1_n11574_6541# m1_n11242_6204# 0.1165f
C6 m1_n11574_6940# m1_n11242_6204# 0.05124f
C7 out B 0.01057f
C8 m1_n11574_6541# B 0.60521f
C9 B m1_n11574_6940# 0.12534f
C10 m1_n10970_6203# nfet_2/a_94_0# 0.0162f
C11 m1_n11574_6541# m1_n11574_6940# 0.16021f
C12 VDD m1_n10970_6203# 0.21656f
C13 m1_n10970_6203# m1_n11242_6204# 0.51838f
C14 m1_n10970_6203# B 0.09741f
C15 VDD m1_n11242_6204# 0.19748f
C16 m1_n10970_6203# out 0.37309f
C17 m1_n11574_6541# m1_n10970_6203# 0.10227f
C18 VDD B 0.03284f
C19 out GND 0.36295f
C20 VDD GND -0.70265f
C21 m1_n11242_6204# GND 0.33396f
C22 m1_n11574_6940# GND 0.1686f
C23 m1_n10970_6203# GND 0.59788f
C24 m1_n11574_6541# GND 0.20722f
C25 nfet_2/a_94_0# GND -0.03108f
C26 B GND 0.10547f
C27 nfet_1/a_94_0# GND -0.02957f
.ends

.subckt tm_to_bin2 VDD comp[0] comp[1] comp[2] comp[3] comp[4] comp[5] comp[6] comp[7] comp[8] comp[9] comp[10] comp[11] comp[12] comp[13] comp[14] comp[15] comp[16] comp[17] comp[18] comp[19] comp[20] comp[21] comp[22] comp[23] comp[24] comp[25] comp[26] comp[27] comp[28] comp[29] comp[30] comp[31] comp[32] comp[33] comp[34] comp[35] comp[36] comp[37] comp[38] comp[39] comp[40] comp[41] comp[42] comp[43] comp[44] comp[45] comp[46] comp[47] comp[48] comp[49] comp[50] comp[51] comp[52] comp[53] comp[54] comp[55] comp[56] comp[57] comp[58] comp[59] comp[60] comp[61] comp[62] GND wl[62] wl[61] wl[60] wl[59] wl[58] wl[57] wl[56] wl[55] wl[54] wl[53] wl[52] wl[51] wl[50] wl[49] wl[48] wl[47] wl[46] wl[45] wl[44] wl[43] wl[42] wl[41] wl[40] wl[39] wl[38] wl[37] wl[36] wl[35] wl[34] wl[33] wl[32] wl[31] wl[30] wl[29] wl[28] wl[27] wl[26] wl[25] wl[24] wl[23] wl[22] wl[21] wl[20] wl[19] wl[18] wl[17] wl[16] wl[15] wl[14] wl[13] wl[12] wl[11] wl[10] wl[9] wl[8] wl[7] wl[6] wl[5] wl[4] wl[3] wl[2] wl[1] wl[0]

XNAND3_60 NAND3_9/VDD comp[2] wl[2] comp[1] NAND3_60/m1_n10970_6203# NAND3_60/m1_n11242_6204#
+ comp[3] VSUBS NAND3
XNAND3_50 NAND3_9/VDD comp[12] wl[12] comp[11] NAND3_50/m1_n10970_6203# NAND3_50/m1_n11242_6204#
+ comp[13] VSUBS NAND3
XNAND3_61 NAND3_9/VDD comp[1] wl[1] comp[0] NAND3_61/m1_n10970_6203# NAND3_61/m1_n11242_6204#
+ comp[2] VSUBS NAND3
XNAND3_40 NAND3_9/VDD comp[22] wl[22] comp[21] NAND3_40/m1_n10970_6203# NAND3_40/m1_n11242_6204#
+ comp[23] VSUBS NAND3
XNAND3_51 NAND3_9/VDD comp[11] wl[11] comp[10] NAND3_51/m1_n10970_6203# NAND3_51/m1_n11242_6204#
+ comp[12] VSUBS NAND3
XNAND3_62 NAND3_9/VDD comp[0] wl[0] VDD NAND3_62/m1_n10970_6203# NAND3_62/m1_n11242_6204#
+ comp[1] VSUBS NAND3
XNAND3_30 NAND3_9/VDD comp[32] wl[32] comp[31] NAND3_30/m1_n10970_6203# NAND3_30/m1_n11242_6204#
+ comp[33] VSUBS NAND3
XNAND3_41 NAND3_9/VDD comp[21] wl[21] comp[20] NAND3_41/m1_n10970_6203# NAND3_41/m1_n11242_6204#
+ comp[22] VSUBS NAND3
XNAND3_52 NAND3_9/VDD comp[10] wl[10] comp[9] NAND3_52/m1_n10970_6203# NAND3_52/m1_n11242_6204#
+ comp[11] VSUBS NAND3
XNAND3_20 NAND3_9/VDD comp[42] wl[42] comp[41] NAND3_20/m1_n10970_6203# NAND3_20/m1_n11242_6204#
+ comp[43] VSUBS NAND3
XNAND3_31 NAND3_9/VDD comp[31] wl[31] comp[30] NAND3_31/m1_n10970_6203# NAND3_31/m1_n11242_6204#
+ comp[32] VSUBS NAND3
XNAND3_42 NAND3_9/VDD comp[20] wl[20] comp[19] NAND3_42/m1_n10970_6203# NAND3_42/m1_n11242_6204#
+ comp[21] VSUBS NAND3
XNAND3_53 NAND3_9/VDD comp[9] wl[9] comp[8] NAND3_53/m1_n10970_6203# NAND3_53/m1_n11242_6204#
+ comp[10] VSUBS NAND3
XNAND3_0 NAND3_9/VDD comp[62] wl[62] comp[61] NAND3_0/m1_n10970_6203# NAND3_0/m1_n11242_6204#
+ GND VSUBS NAND3
XNAND3_10 NAND3_9/VDD comp[52] wl[52] comp[51] NAND3_10/m1_n10970_6203# NAND3_10/m1_n11242_6204#
+ comp[53] VSUBS NAND3
XNAND3_21 NAND3_9/VDD comp[41] wl[41] comp[40] NAND3_21/m1_n10970_6203# NAND3_21/m1_n11242_6204#
+ comp[42] VSUBS NAND3
XNAND3_32 NAND3_9/VDD comp[30] wl[30] comp[29] NAND3_32/m1_n10970_6203# NAND3_32/m1_n11242_6204#
+ comp[31] VSUBS NAND3
XNAND3_43 NAND3_9/VDD comp[19] wl[19] comp[18] NAND3_43/m1_n10970_6203# NAND3_43/m1_n11242_6204#
+ comp[20] VSUBS NAND3
XNAND3_54 NAND3_9/VDD comp[8] wl[8] comp[7] NAND3_54/m1_n10970_6203# NAND3_54/m1_n11242_6204#
+ comp[9] VSUBS NAND3
XNAND3_1 NAND3_9/VDD comp[61] wl[61] comp[60] NAND3_1/m1_n10970_6203# NAND3_1/m1_n11242_6204#
+ comp[62] VSUBS NAND3
XNAND3_11 NAND3_9/VDD comp[51] wl[51] comp[50] NAND3_11/m1_n10970_6203# NAND3_11/m1_n11242_6204#
+ comp[52] VSUBS NAND3
XNAND3_22 NAND3_9/VDD comp[40] wl[40] comp[39] NAND3_22/m1_n10970_6203# NAND3_22/m1_n11242_6204#
+ comp[41] VSUBS NAND3
XNAND3_33 NAND3_9/VDD comp[29] wl[29] comp[28] NAND3_33/m1_n10970_6203# NAND3_33/m1_n11242_6204#
+ comp[30] VSUBS NAND3
XNAND3_44 NAND3_9/VDD comp[18] wl[18] comp[17] NAND3_44/m1_n10970_6203# NAND3_44/m1_n11242_6204#
+ comp[19] VSUBS NAND3
XNAND3_55 NAND3_9/VDD comp[7] wl[7] comp[6] NAND3_55/m1_n10970_6203# NAND3_55/m1_n11242_6204#
+ comp[8] VSUBS NAND3
XNAND3_2 NAND3_9/VDD comp[60] wl[60] comp[59] NAND3_2/m1_n10970_6203# NAND3_2/m1_n11242_6204#
+ comp[61] VSUBS NAND3
XNAND3_12 NAND3_9/VDD comp[50] wl[50] comp[49] NAND3_12/m1_n10970_6203# NAND3_12/m1_n11242_6204#
+ comp[51] VSUBS NAND3
XNAND3_23 NAND3_9/VDD comp[39] wl[39] comp[38] NAND3_23/m1_n10970_6203# NAND3_23/m1_n11242_6204#
+ comp[40] VSUBS NAND3
XNAND3_34 NAND3_9/VDD comp[28] wl[28] comp[27] NAND3_34/m1_n10970_6203# NAND3_34/m1_n11242_6204#
+ comp[29] VSUBS NAND3
XNAND3_45 NAND3_9/VDD comp[17] wl[17] comp[16] NAND3_45/m1_n10970_6203# NAND3_45/m1_n11242_6204#
+ comp[18] VSUBS NAND3
XNAND3_56 NAND3_9/VDD comp[6] wl[6] comp[5] NAND3_56/m1_n10970_6203# NAND3_56/m1_n11242_6204#
+ comp[7] VSUBS NAND3
XNAND3_3 NAND3_9/VDD comp[59] wl[59] comp[58] NAND3_3/m1_n10970_6203# NAND3_3/m1_n11242_6204#
+ comp[60] VSUBS NAND3
XNAND3_13 NAND3_9/VDD comp[49] wl[49] comp[48] NAND3_13/m1_n10970_6203# NAND3_13/m1_n11242_6204#
+ comp[50] VSUBS NAND3
XNAND3_14 NAND3_9/VDD comp[48] wl[48] comp[47] NAND3_14/m1_n10970_6203# NAND3_14/m1_n11242_6204#
+ comp[49] VSUBS NAND3
XNAND3_24 NAND3_9/VDD comp[38] wl[38] comp[37] NAND3_24/m1_n10970_6203# NAND3_24/m1_n11242_6204#
+ comp[39] VSUBS NAND3
XNAND3_25 NAND3_9/VDD comp[37] wl[37] comp[36] NAND3_25/m1_n10970_6203# NAND3_25/m1_n11242_6204#
+ comp[38] VSUBS NAND3
XNAND3_35 NAND3_9/VDD comp[27] wl[27] comp[26] NAND3_35/m1_n10970_6203# NAND3_35/m1_n11242_6204#
+ comp[28] VSUBS NAND3
XNAND3_36 NAND3_9/VDD comp[26] wl[26] comp[25] NAND3_36/m1_n10970_6203# NAND3_36/m1_n11242_6204#
+ comp[27] VSUBS NAND3
XNAND3_46 NAND3_9/VDD comp[16] wl[16] comp[15] NAND3_46/m1_n10970_6203# NAND3_46/m1_n11242_6204#
+ comp[17] VSUBS NAND3
XNAND3_47 NAND3_9/VDD comp[15] wl[15] comp[14] NAND3_47/m1_n10970_6203# NAND3_47/m1_n11242_6204#
+ comp[16] VSUBS NAND3
XNAND3_57 NAND3_9/VDD comp[5] wl[5] comp[4] NAND3_57/m1_n10970_6203# NAND3_57/m1_n11242_6204#
+ comp[6] VSUBS NAND3
XNAND3_58 NAND3_9/VDD comp[4] wl[4] comp[3] NAND3_58/m1_n10970_6203# NAND3_58/m1_n11242_6204#
+ comp[5] VSUBS NAND3
XNAND3_4 NAND3_9/VDD comp[58] wl[58] comp[57] NAND3_4/m1_n10970_6203# NAND3_4/m1_n11242_6204#
+ comp[59] VSUBS NAND3
XNAND3_15 NAND3_9/VDD comp[47] wl[47] comp[46] NAND3_15/m1_n10970_6203# NAND3_15/m1_n11242_6204#
+ comp[48] VSUBS NAND3
XNAND3_26 NAND3_9/VDD comp[36] wl[36] comp[35] NAND3_26/m1_n10970_6203# NAND3_26/m1_n11242_6204#
+ comp[37] VSUBS NAND3
XNAND3_37 NAND3_9/VDD comp[25] wl[25] comp[24] NAND3_37/m1_n10970_6203# NAND3_37/m1_n11242_6204#
+ comp[26] VSUBS NAND3
XNAND3_48 NAND3_9/VDD comp[14] wl[14] comp[13] NAND3_48/m1_n10970_6203# NAND3_48/m1_n11242_6204#
+ comp[15] VSUBS NAND3
XNAND3_59 NAND3_9/VDD comp[3] wl[3] comp[2] NAND3_59/m1_n10970_6203# NAND3_59/m1_n11242_6204#
+ comp[4] VSUBS NAND3
XNAND3_5 NAND3_9/VDD comp[57] wl[57] comp[56] NAND3_5/m1_n10970_6203# NAND3_5/m1_n11242_6204#
+ comp[58] VSUBS NAND3
XNAND3_6 NAND3_9/VDD comp[56] wl[56] comp[55] NAND3_6/m1_n10970_6203# NAND3_6/m1_n11242_6204#
+ comp[57] VSUBS NAND3
XNAND3_16 NAND3_9/VDD comp[46] wl[46] comp[45] NAND3_16/m1_n10970_6203# NAND3_16/m1_n11242_6204#
+ comp[47] VSUBS NAND3
XNAND3_27 NAND3_9/VDD comp[35] wl[35] comp[34] NAND3_27/m1_n10970_6203# NAND3_27/m1_n11242_6204#
+ comp[36] VSUBS NAND3
XNAND3_38 NAND3_9/VDD comp[24] wl[24] comp[23] NAND3_38/m1_n10970_6203# NAND3_38/m1_n11242_6204#
+ comp[25] VSUBS NAND3
XNAND3_49 NAND3_9/VDD comp[13] wl[13] comp[12] NAND3_49/m1_n10970_6203# NAND3_49/m1_n11242_6204#
+ comp[14] VSUBS NAND3
XNAND3_7 NAND3_9/VDD comp[55] wl[55] comp[54] NAND3_7/m1_n10970_6203# NAND3_7/m1_n11242_6204#
+ comp[56] VSUBS NAND3
XNAND3_17 NAND3_9/VDD comp[45] wl[45] comp[44] NAND3_17/m1_n10970_6203# NAND3_17/m1_n11242_6204#
+ comp[46] VSUBS NAND3
XNAND3_28 NAND3_9/VDD comp[34] wl[34] comp[33] NAND3_28/m1_n10970_6203# NAND3_28/m1_n11242_6204#
+ comp[35] VSUBS NAND3
XNAND3_39 NAND3_9/VDD comp[23] wl[23] comp[22] NAND3_39/m1_n10970_6203# NAND3_39/m1_n11242_6204#
+ comp[24] VSUBS NAND3
XNAND3_8 NAND3_9/VDD comp[54] wl[54] comp[53] NAND3_8/m1_n10970_6203# NAND3_8/m1_n11242_6204#
+ comp[55] VSUBS NAND3
XNAND3_18 NAND3_9/VDD comp[44] wl[44] comp[43] NAND3_18/m1_n10970_6203# NAND3_18/m1_n11242_6204#
+ comp[45] VSUBS NAND3
XNAND3_29 NAND3_9/VDD comp[33] wl[33] comp[32] NAND3_29/m1_n10970_6203# NAND3_29/m1_n11242_6204#
+ comp[34] VSUBS NAND3
XNAND3_9 NAND3_9/VDD comp[53] wl[53] comp[52] NAND3_9/m1_n10970_6203# NAND3_9/m1_n11242_6204#
+ comp[54] VSUBS NAND3
XNAND3_19 NAND3_9/VDD comp[43] wl[43] comp[42] NAND3_19/m1_n10970_6203# NAND3_19/m1_n11242_6204#
+ comp[44] VSUBS NAND3
C0 wl[3] NAND3_9/VDD 0.03446f
C1 NAND3_35/m1_n11242_6204# NAND3_9/VDD 0.01389f
C2 comp[1] NAND3_9/VDD 0.02071f
C3 NAND3_22/m1_n10970_6203# NAND3_21/m1_n10970_6203# 0.04082f
C4 NAND3_9/m1_n11242_6204# comp[52] 0.03186f
C5 wl[27] NAND3_9/VDD 0.03446f
C6 NAND3_29/m1_n11242_6204# NAND3_9/VDD 0.01389f
C7 NAND3_11/m1_n10970_6203# NAND3_9/VDD 0.07502f
C8 wl[37] NAND3_9/VDD 0.03446f
C9 NAND3_9/VDD NAND3_22/m1_n11242_6204# 0.01389f
C10 NAND3_11/m1_n10970_6203# NAND3_10/m1_n10970_6203# 0.09992f
C11 comp[8] NAND3_9/VDD 0.01576f
C12 wl[12] NAND3_9/VDD 0.03446f
C13 comp[36] comp[38] 0.05611f
C14 VDD comp[0] 0.03846f
C15 NAND3_1/m1_n10970_6203# NAND3_9/VDD 0.07502f
C16 comp[37] comp[38] 0.98258f
C17 comp[1] comp[2] 0.98258f
C18 comp[48] comp[49] 1.16907f
C19 NAND3_54/m1_n10970_6203# NAND3_9/VDD 0.07502f
C20 NAND3_58/m1_n11242_6204# NAND3_9/VDD 0.01389f
C21 NAND3_39/m1_n10970_6203# NAND3_9/VDD 0.07502f
C22 comp[15] comp[14] 0.53753f
C23 NAND3_12/m1_n11242_6204# NAND3_13/m1_n11242_6204# 0.02886f
C24 NAND3_9/VDD NAND3_42/m1_n10970_6203# 0.07502f
C25 comp[30] comp[31] 1.16908f
C26 NAND3_9/VDD NAND3_20/m1_n11242_6204# 0.01389f
C27 wl[54] NAND3_9/VDD 0.03446f
C28 NAND3_62/m1_n11242_6204# comp[0] 0.05413f
C29 comp[26] comp[24] 0.05611f
C30 NAND3_8/m1_n11242_6204# NAND3_9/VDD 0.01389f
C31 comp[33] NAND3_9/VDD 0.15022f
C32 comp[40] comp[42] 0.26719f
C33 NAND3_2/m1_n10970_6203# NAND3_3/m1_n10970_6203# 0.09992f
C34 comp[47] comp[48] 0.48492f
C35 NAND3_55/m1_n11242_6204# NAND3_9/VDD 0.01389f
C36 comp[41] comp[42] 0.48492f
C37 NAND3_16/m1_n11242_6204# comp[45] 0.0227f
C38 NAND3_9/m1_n11242_6204# comp[54] 0.04042f
C39 comp[3] NAND3_60/m1_n11242_6204# 0.04688f
C40 wl[9] NAND3_9/VDD 0.03446f
C41 NAND3_33/m1_n11242_6204# NAND3_9/VDD 0.01389f
C42 NAND3_9/VDD wl[20] 0.03446f
C43 comp[40] comp[39] 0.90907f
C44 NAND3_9/m1_n11242_6204# NAND3_10/m1_n11242_6204# 0.01033f
C45 comp[15] NAND3_47/m1_n11242_6204# 0.07714f
C46 NAND3_9/VDD comp[30] 0.15022f
C47 NAND3_28/m1_n11242_6204# comp[34] 0.04563f
C48 NAND3_2/m1_n11242_6204# NAND3_3/m1_n11242_6204# 0.02886f
C49 comp[47] comp[49] 0.02007f
C50 NAND3_9/VDD NAND3_60/m1_n10970_6203# 0.07502f
C51 NAND3_38/m1_n10970_6203# NAND3_9/VDD 0.07502f
C52 comp[0] NAND3_61/m1_n11242_6204# 0.05586f
C53 comp[60] comp[62] 0.05611f
C54 NAND3_9/VDD NAND3_0/m1_n10970_6203# 0.05019f
C55 NAND3_9/VDD comp[53] 0.01576f
C56 comp[23] comp[24] 0.48492f
C57 comp[27] NAND3_35/m1_n11242_6204# 0.07714f
C58 NAND3_25/m1_n11242_6204# NAND3_26/m1_n11242_6204# 0.01033f
C59 NAND3_16/m1_n11242_6204# comp[46] 0.04563f
C60 wl[57] NAND3_9/VDD 0.03446f
C61 comp[36] comp[34] 0.26719f
C62 comp[9] NAND3_52/m1_n11242_6204# 0.0227f
C63 comp[35] NAND3_9/VDD 0.01576f
C64 NAND3_55/m1_n11242_6204# NAND3_56/m1_n11242_6204# 0.01033f
C65 comp[15] comp[16] 0.90907f
C66 NAND3_4/m1_n10970_6203# NAND3_9/VDD 0.07502f
C67 NAND3_57/m1_n11242_6204# NAND3_9/VDD 0.01389f
C68 NAND3_50/m1_n11242_6204# NAND3_51/m1_n11242_6204# 0.02886f
C69 NAND3_30/m1_n11242_6204# NAND3_31/m1_n11242_6204# 0.02886f
C70 NAND3_9/VDD wl[10] 0.03446f
C71 NAND3_59/m1_n11242_6204# NAND3_9/VDD 0.01389f
C72 NAND3_9/VDD comp[25] 0.02071f
C73 comp[12] comp[14] 0.05611f
C74 NAND3_14/m1_n10970_6203# NAND3_9/VDD 0.07502f
C75 comp[10] NAND3_51/m1_n11242_6204# 0.03186f
C76 NAND3_9/VDD NAND3_45/m1_n10970_6203# 0.07502f
C77 NAND3_6/m1_n10970_6203# NAND3_7/m1_n10970_6203# 0.09992f
C78 comp[40] NAND3_9/VDD 0.09775f
C79 NAND3_1/m1_n11242_6204# NAND3_2/m1_n11242_6204# 0.01033f
C80 comp[59] comp[61] 0.02007f
C81 comp[41] NAND3_9/VDD 0.01576f
C82 comp[55] comp[53] 0.02007f
C83 NAND3_26/m1_n11242_6204# NAND3_9/VDD 0.01389f
C84 comp[36] comp[37] 1.16908f
C85 NAND3_6/m1_n11242_6204# NAND3_9/VDD 0.01389f
C86 comp[16] comp[14] 0.25793f
C87 comp[15] NAND3_9/VDD 0.15022f
C88 NAND3_9/VDD wl[31] 0.03446f
C89 comp[13] comp[14] 0.98258f
C90 comp[53] comp[52] 1.23267f
C91 NAND3_56/m1_n11242_6204# NAND3_57/m1_n11242_6204# 0.02886f
C92 NAND3_9/VDD NAND3_20/m1_n10970_6203# 0.07502f
C93 comp[19] NAND3_43/m1_n11242_6204# 0.01965f
C94 NAND3_32/m1_n11242_6204# NAND3_33/m1_n11242_6204# 0.02886f
C95 NAND3_33/m1_n10970_6203# NAND3_9/VDD 0.07502f
C96 comp[9] comp[8] 0.53753f
C97 NAND3_13/m1_n11242_6204# NAND3_9/VDD 0.01389f
C98 comp[54] NAND3_8/m1_n11242_6204# 0.07767f
C99 NAND3_32/m1_n11242_6204# comp[30] 0.07767f
C100 NAND3_23/m1_n11242_6204# comp[39] 0.07714f
C101 NAND3_12/m1_n11242_6204# NAND3_9/VDD 0.01389f
C102 comp[12] NAND3_49/m1_n11242_6204# 0.05586f
C103 comp[15] NAND3_46/m1_n11242_6204# 0.0227f
C104 comp[19] comp[20] 0.98258f
C105 NAND3_33/m1_n11242_6204# comp[28] 0.03186f
C106 comp[31] comp[32] 0.98258f
C107 NAND3_8/m1_n10970_6203# NAND3_7/m1_n10970_6203# 0.04082f
C108 NAND3_17/m1_n11242_6204# NAND3_9/VDD 0.01389f
C109 NAND3_26/m1_n11242_6204# NAND3_27/m1_n11242_6204# 0.02886f
C110 wl[6] NAND3_9/VDD 0.03446f
C111 NAND3_9/VDD comp[14] 0.01576f
C112 NAND3_24/m1_n10970_6203# NAND3_9/VDD 0.07502f
C113 comp[28] comp[30] 0.26719f
C114 comp[12] comp[13] 1.16908f
C115 NAND3_9/VDD NAND3_43/m1_n10970_6203# 0.07502f
C116 comp[55] NAND3_6/m1_n11242_6204# 0.01768f
C117 wl[58] NAND3_9/VDD 0.03446f
C118 NAND3_9/VDD wl[42] 0.03446f
C119 NAND3_21/m1_n11242_6204# NAND3_22/m1_n11242_6204# 0.01033f
C120 NAND3_15/m1_n11242_6204# comp[46] 0.03186f
C121 NAND3_9/VDD NAND3_7/m1_n10970_6203# 0.07502f
C122 NAND3_48/m1_n10970_6203# NAND3_9/VDD 0.07502f
C123 comp[54] comp[53] 0.48492f
C124 NAND3_49/m1_n11242_6204# comp[13] 0.01965f
C125 NAND3_9/VDD comp[32] 0.01576f
C126 NAND3_25/m1_n10970_6203# NAND3_24/m1_n10970_6203# 0.09992f
C127 NAND3_9/VDD comp[42] 0.15022f
C128 comp[22] comp[23] 1.23267f
C129 NAND3_21/m1_n11242_6204# NAND3_20/m1_n11242_6204# 0.02886f
C130 NAND3_47/m1_n11242_6204# NAND3_9/VDD 0.01389f
C131 NAND3_18/m1_n10970_6203# NAND3_9/VDD 0.07502f
C132 comp[4] comp[3] 0.90907f
C133 NAND3_37/m1_n11242_6204# comp[24] 0.05586f
C134 NAND3_39/m1_n11242_6204# comp[24] 0.04042f
C135 comp[12] NAND3_9/VDD 0.15022f
C136 NAND3_9/VDD comp[39] 0.15022f
C137 NAND3_6/m1_n10970_6203# NAND3_9/VDD 0.07502f
C138 comp[7] NAND3_9/VDD 0.02071f
C139 NAND3_23/m1_n11242_6204# NAND3_9/VDD 0.01389f
C140 NAND3_11/m1_n11242_6204# NAND3_12/m1_n11242_6204# 0.01033f
C141 NAND3_49/m1_n11242_6204# NAND3_9/VDD 0.01389f
C142 NAND3_40/m1_n11242_6204# NAND3_9/VDD 0.01389f
C143 NAND3_9/VDD NAND3_31/m1_n10970_6203# 0.07502f
C144 NAND3_2/m1_n10970_6203# NAND3_1/m1_n10970_6203# 0.04082f
C145 comp[19] comp[17] 0.02007f
C146 NAND3_41/m1_n10970_6203# NAND3_9/VDD 0.07502f
C147 NAND3_40/m1_n11242_6204# comp[21] 0.0227f
C148 NAND3_25/m1_n11242_6204# NAND3_9/VDD 0.01389f
C149 comp[22] comp[24] 0.26719f
C150 NAND3_47/m1_n11242_6204# NAND3_46/m1_n11242_6204# 0.02886f
C151 comp[16] NAND3_9/VDD 0.09775f
C152 NAND3_55/m1_n11242_6204# NAND3_54/m1_n11242_6204# 0.02886f
C153 comp[13] NAND3_9/VDD 0.02071f
C154 comp[48] comp[46] 0.26719f
C155 NAND3_15/m1_n10970_6203# NAND3_14/m1_n10970_6203# 0.09992f
C156 NAND3_18/m1_n11242_6204# NAND3_17/m1_n11242_6204# 0.01033f
C157 comp[1] NAND3_61/m1_n11242_6204# 0.01965f
C158 NAND3_13/m1_n11242_6204# NAND3_14/m1_n11242_6204# 0.01033f
C159 NAND3_61/m1_n10970_6203# NAND3_60/m1_n10970_6203# 0.09992f
C160 NAND3_9/VDD comp[31] 0.02071f
C161 comp[44] comp[45] 0.53753f
C162 NAND3_8/m1_n11242_6204# NAND3_7/m1_n11242_6204# 0.01033f
C163 NAND3_58/m1_n10970_6203# NAND3_59/m1_n10970_6203# 0.09992f
C164 comp[6] comp[4] 0.26719f
C165 NAND3_55/m1_n10970_6203# NAND3_56/m1_n10970_6203# 0.04082f
C166 NAND3_9/VDD comp[56] 0.01576f
C167 NAND3_13/m1_n10970_6203# NAND3_12/m1_n10970_6203# 0.09992f
C168 comp[41] comp[43] 0.02007f
C169 NAND3_16/m1_n10970_6203# NAND3_9/VDD 0.07502f
C170 NAND3_8/m1_n10970_6203# NAND3_9/VDD 0.07502f
C171 NAND3_46/m1_n11242_6204# comp[16] 0.04563f
C172 wl[19] NAND3_9/VDD 0.03446f
C173 NAND3_9/VDD wl[30] 0.03446f
C174 NAND3_35/m1_n11242_6204# NAND3_34/m1_n11242_6204# 0.02886f
C175 comp[30] NAND3_31/m1_n11242_6204# 0.05586f
C176 NAND3_9/VDD NAND3_10/m1_n10970_6203# 0.07502f
C177 comp[16] comp[18] 0.26719f
C178 NAND3_9/VDD comp[21] 0.15022f
C179 NAND3_53/m1_n10970_6203# NAND3_52/m1_n10970_6203# 0.09992f
C180 NAND3_40/m1_n11242_6204# NAND3_41/m1_n11242_6204# 0.02886f
C181 NAND3_9/VDD NAND3_42/m1_n11242_6204# 0.01389f
C182 NAND3_9/VDD wl[21] 0.03446f
C183 comp[46] comp[44] 0.25793f
C184 NAND3_9/VDD comp[50] 0.01576f
C185 NAND3_21/m1_n11242_6204# comp[40] 0.03186f
C186 comp[47] comp[46] 1.23267f
C187 NAND3_53/m1_n11242_6204# NAND3_52/m1_n11242_6204# 0.02886f
C188 NAND3_51/m1_n11242_6204# NAND3_52/m1_n11242_6204# 0.01033f
C189 NAND3_44/m1_n10970_6203# NAND3_45/m1_n10970_6203# 0.09992f
C190 NAND3_42/m1_n11242_6204# comp[21] 0.04688f
C191 comp[2] NAND3_9/VDD 0.01576f
C192 comp[10] comp[11] 1.23267f
C193 NAND3_57/m1_n10970_6203# NAND3_9/VDD 0.07502f
C194 NAND3_30/m1_n10970_6203# NAND3_31/m1_n10970_6203# 0.09992f
C195 comp[10] NAND3_52/m1_n11242_6204# 0.04563f
C196 NAND3_16/m1_n11242_6204# NAND3_17/m1_n11242_6204# 0.02886f
C197 NAND3_25/m1_n10970_6203# NAND3_9/VDD 0.07502f
C198 comp[57] NAND3_6/m1_n11242_6204# 0.04688f
C199 NAND3_9/VDD wl[62] 0.02351f
C200 NAND3_51/m1_n10970_6203# NAND3_9/VDD 0.07502f
C201 NAND3_9/VDD comp[60] 0.15022f
C202 NAND3_46/m1_n11242_6204# NAND3_9/VDD 0.01389f
C203 comp[55] comp[56] 0.98258f
C204 comp[61] comp[62] 0.9802f
C205 NAND3_56/m1_n11242_6204# NAND3_9/VDD 0.01389f
C206 NAND3_36/m1_n10970_6203# NAND3_37/m1_n10970_6203# 0.09992f
C207 NAND3_9/VDD comp[18] 0.15022f
C208 NAND3_27/m1_n11242_6204# NAND3_9/VDD 0.01389f
C209 comp[1] NAND3_60/m1_n11242_6204# 0.01768f
C210 wl[47] NAND3_9/VDD 0.03446f
C211 NAND3_37/m1_n11242_6204# NAND3_36/m1_n11242_6204# 0.02886f
C212 NAND3_19/m1_n11242_6204# NAND3_20/m1_n11242_6204# 0.01033f
C213 comp[55] NAND3_9/VDD 0.02071f
C214 NAND3_58/m1_n11242_6204# comp[3] 0.0227f
C215 comp[22] comp[20] 0.25793f
C216 NAND3_34/m1_n11242_6204# NAND3_33/m1_n11242_6204# 0.01033f
C217 NAND3_27/m1_n10970_6203# NAND3_9/VDD 0.07502f
C218 NAND3_29/m1_n11242_6204# NAND3_28/m1_n11242_6204# 0.02886f
C219 NAND3_9/VDD NAND3_41/m1_n11242_6204# 0.01389f
C220 comp[22] NAND3_39/m1_n11242_6204# 0.03186f
C221 NAND3_9/VDD comp[52] 0.09775f
C222 comp[6] comp[5] 0.48492f
C223 NAND3_5/m1_n10970_6203# NAND3_4/m1_n10970_6203# 0.09992f
C224 comp[21] NAND3_41/m1_n11242_6204# 0.07714f
C225 NAND3_9/VDD wl[22] 0.03446f
C226 NAND3_6/m1_n11242_6204# NAND3_7/m1_n11242_6204# 0.02886f
C227 comp[42] comp[43] 1.16908f
C228 NAND3_11/m1_n11242_6204# NAND3_9/VDD 0.01389f
C229 NAND3_48/m1_n10970_6203# NAND3_47/m1_n10970_6203# 0.04082f
C230 NAND3_9/VDD NAND3_22/m1_n10970_6203# 0.07502f
C231 NAND3_42/m1_n11242_6204# NAND3_41/m1_n11242_6204# 0.01033f
C232 comp[50] comp[52] 0.25793f
C233 NAND3_30/m1_n10970_6203# NAND3_9/VDD 0.07502f
C234 NAND3_34/m1_n10970_6203# NAND3_35/m1_n10970_6203# 0.09992f
C235 NAND3_18/m1_n11242_6204# NAND3_9/VDD 0.01389f
C236 NAND3_44/m1_n10970_6203# NAND3_43/m1_n10970_6203# 0.04082f
C237 NAND3_40/m1_n10970_6203# NAND3_39/m1_n10970_6203# 0.04082f
C238 comp[38] comp[40] 0.25793f
C239 comp[33] comp[34] 0.90907f
C240 comp[27] NAND3_9/VDD 0.15022f
C241 NAND3_4/m1_n11242_6204# NAND3_9/VDD 0.01389f
C242 NAND3_45/m1_n11242_6204# comp[16] 0.03186f
C243 NAND3_44/m1_n11242_6204# NAND3_9/VDD 0.01389f
C244 comp[10] comp[8] 0.25793f
C245 NAND3_38/m1_n11242_6204# NAND3_9/VDD 0.01389f
C246 comp[8] comp[6] 0.05611f
C247 NAND3_32/m1_n11242_6204# NAND3_9/VDD 0.01389f
C248 wl[39] NAND3_9/VDD 0.03446f
C249 comp[33] NAND3_28/m1_n11242_6204# 0.0227f
C250 comp[54] comp[56] 0.05611f
C251 NAND3_21/m1_n11242_6204# comp[42] 0.04042f
C252 NAND3_14/m1_n11242_6204# NAND3_9/VDD 0.01389f
C253 comp[26] comp[25] 0.98258f
C254 comp[58] comp[56] 0.25793f
C255 NAND3_36/m1_n10970_6203# NAND3_35/m1_n10970_6203# 0.04082f
C256 wl[1] NAND3_9/VDD 0.03446f
C257 comp[54] NAND3_9/VDD 0.15022f
C258 wl[55] NAND3_9/VDD 0.03446f
C259 comp[28] NAND3_9/VDD 0.09775f
C260 NAND3_9/VDD NAND3_10/m1_n11242_6204# 0.01389f
C261 NAND3_16/m1_n10970_6203# NAND3_15/m1_n10970_6203# 0.04082f
C262 NAND3_9/m1_n10970_6203# NAND3_8/m1_n10970_6203# 0.09992f
C263 NAND3_11/m1_n10970_6203# NAND3_12/m1_n10970_6203# 0.04082f
C264 comp[58] NAND3_9/VDD 0.09775f
C265 NAND3_45/m1_n11242_6204# NAND3_9/VDD 0.01389f
C266 comp[34] comp[35] 1.23267f
C267 NAND3_44/m1_n11242_6204# comp[18] 0.07767f
C268 NAND3_29/m1_n10970_6203# NAND3_9/VDD 0.07502f
C269 NAND3_24/m1_n11242_6204# comp[39] 0.04688f
C270 NAND3_24/m1_n11242_6204# NAND3_23/m1_n11242_6204# 0.01033f
C271 NAND3_9/m1_n10970_6203# NAND3_9/VDD 0.07502f
C272 NAND3_9/m1_n10970_6203# NAND3_10/m1_n10970_6203# 0.04082f
C273 comp[1] comp[0] 1.15516f
C274 NAND3_55/m1_n11242_6204# comp[6] 0.05586f
C275 NAND3_15/m1_n10970_6203# NAND3_9/VDD 0.07502f
C276 comp[7] NAND3_54/m1_n11242_6204# 0.01768f
C277 NAND3_16/m1_n11242_6204# NAND3_9/VDD 0.01389f
C278 NAND3_50/m1_n10970_6203# NAND3_9/VDD 0.07502f
C279 NAND3_3/m1_n11242_6204# NAND3_9/VDD 0.01389f
C280 NAND3_59/m1_n11242_6204# comp[3] 0.07714f
C281 comp[9] NAND3_9/VDD 0.15022f
C282 comp[23] comp[25] 0.02007f
C283 NAND3_9/VDD comp[43] 0.02071f
C284 NAND3_25/m1_n11242_6204# NAND3_24/m1_n11242_6204# 0.02886f
C285 comp[58] comp[60] 0.26719f
C286 NAND3_54/m1_n10970_6203# NAND3_53/m1_n10970_6203# 0.04082f
C287 NAND3_59/m1_n11242_6204# NAND3_60/m1_n11242_6204# 0.01033f
C288 NAND3_45/m1_n11242_6204# NAND3_46/m1_n11242_6204# 0.01033f
C289 comp[29] comp[30] 0.48492f
C290 NAND3_5/m1_n11242_6204# NAND3_6/m1_n11242_6204# 0.01033f
C291 NAND3_38/m1_n10970_6203# NAND3_37/m1_n10970_6203# 0.04082f
C292 wl[52] NAND3_9/VDD 0.03446f
C293 comp[55] comp[54] 1.16908f
C294 comp[48] NAND3_13/m1_n11242_6204# 0.05586f
C295 comp[57] comp[56] 0.53753f
C296 NAND3_59/m1_n10970_6203# NAND3_60/m1_n10970_6203# 0.04082f
C297 NAND3_51/m1_n10970_6203# NAND3_50/m1_n10970_6203# 0.09992f
C298 comp[36] comp[35] 0.48492f
C299 NAND3_47/m1_n10970_6203# NAND3_9/VDD 0.07502f
C300 NAND3_3/m1_n11242_6204# comp[60] 0.04042f
C301 NAND3_45/m1_n11242_6204# comp[18] 0.04042f
C302 NAND3_46/m1_n10970_6203# NAND3_45/m1_n10970_6203# 0.04082f
C303 wl[18] NAND3_9/VDD 0.03446f
C304 comp[37] comp[35] 0.02007f
C305 wl[33] NAND3_9/VDD 0.03446f
C306 wl[36] NAND3_9/VDD 0.03446f
C307 NAND3_23/m1_n10970_6203# NAND3_24/m1_n10970_6203# 0.04082f
C308 comp[46] comp[45] 0.90907f
C309 comp[54] comp[52] 0.26719f
C310 NAND3_21/m1_n11242_6204# NAND3_9/VDD 0.01389f
C311 comp[24] comp[25] 1.16908f
C312 comp[38] comp[39] 0.53753f
C313 NAND3_10/m1_n11242_6204# comp[52] 0.04563f
C314 NAND3_44/m1_n10970_6203# NAND3_9/VDD 0.07502f
C315 comp[57] NAND3_9/VDD 0.15022f
C316 comp[6] NAND3_57/m1_n11242_6204# 0.04042f
C317 NAND3_11/m1_n11242_6204# NAND3_10/m1_n11242_6204# 0.02886f
C318 NAND3_62/m1_n10970_6203# NAND3_9/VDD 0.07501f
C319 NAND3_35/m1_n11242_6204# NAND3_36/m1_n11242_6204# 0.01033f
C320 comp[49] NAND3_13/m1_n11242_6204# 0.01965f
C321 NAND3_9/VDD wl[0] 0.03446f
C322 NAND3_61/m1_n10970_6203# NAND3_9/VDD 0.07502f
C323 comp[4] comp[5] 1.23267f
C324 NAND3_12/m1_n11242_6204# comp[49] 0.01768f
C325 comp[31] NAND3_31/m1_n11242_6204# 0.01965f
C326 NAND3_1/m1_n11242_6204# NAND3_9/VDD 0.01389f
C327 NAND3_24/m1_n11242_6204# NAND3_9/VDD 0.01389f
C328 NAND3_6/m1_n10970_6203# NAND3_5/m1_n10970_6203# 0.04082f
C329 wl[49] NAND3_9/VDD 0.03446f
C330 NAND3_29/m1_n11242_6204# NAND3_30/m1_n11242_6204# 0.01033f
C331 NAND3_54/m1_n11242_6204# NAND3_9/VDD 0.01389f
C332 comp[27] comp[28] 0.90907f
C333 NAND3_30/m1_n10970_6203# NAND3_29/m1_n10970_6203# 0.04082f
C334 NAND3_49/m1_n10970_6203# NAND3_48/m1_n10970_6203# 0.09992f
C335 wl[2] NAND3_9/VDD 0.03446f
C336 NAND3_4/m1_n11242_6204# comp[58] 0.04563f
C337 NAND3_26/m1_n11242_6204# comp[36] 0.07767f
C338 NAND3_44/m1_n11242_6204# NAND3_45/m1_n11242_6204# 0.02886f
C339 wl[45] NAND3_9/VDD 0.03446f
C340 NAND3_62/m1_n11242_6204# NAND3_9/VDD 0.01389f
C341 NAND3_18/m1_n11242_6204# comp[43] 0.01768f
C342 NAND3_9/VDD NAND3_7/m1_n11242_6204# 0.01389f
C343 NAND3_4/m1_n11242_6204# NAND3_3/m1_n11242_6204# 0.01033f
C344 NAND3_9/VDD NAND3_31/m1_n11242_6204# 0.01389f
C345 NAND3_1/m1_n11242_6204# comp[60] 0.05586f
C346 NAND3_19/m1_n11242_6204# comp[42] 0.05586f
C347 NAND3_2/m1_n10970_6203# NAND3_9/VDD 0.07502f
C348 NAND3_55/m1_n10970_6203# NAND3_54/m1_n10970_6203# 0.09992f
C349 comp[4] NAND3_58/m1_n11242_6204# 0.04563f
C350 NAND3_4/m1_n10970_6203# NAND3_3/m1_n10970_6203# 0.04082f
C351 comp[33] NAND3_30/m1_n11242_6204# 0.04688f
C352 NAND3_15/m1_n11242_6204# NAND3_9/VDD 0.01389f
C353 comp[34] comp[32] 0.25793f
C354 comp[38] NAND3_9/VDD 0.01576f
C355 NAND3_26/m1_n10970_6203# NAND3_9/VDD 0.07502f
C356 NAND3_61/m1_n11242_6204# NAND3_9/VDD 0.01389f
C357 NAND3_5/m1_n10970_6203# NAND3_9/VDD 0.07502f
C358 comp[58] NAND3_3/m1_n11242_6204# 0.03186f
C359 comp[57] NAND3_4/m1_n11242_6204# 0.0227f
C360 wl[34] NAND3_9/VDD 0.03446f
C361 comp[44] comp[42] 0.05611f
C362 comp[55] NAND3_7/m1_n11242_6204# 0.01965f
C363 NAND3_9/VDD wl[53] 0.03446f
C364 NAND3_25/m1_n10970_6203# NAND3_26/m1_n10970_6203# 0.04082f
C365 wl[44] NAND3_9/VDD 0.03446f
C366 wl[7] NAND3_9/VDD 0.03446f
C367 comp[15] NAND3_48/m1_n11242_6204# 0.04688f
C368 comp[12] NAND3_50/m1_n11242_6204# 0.07767f
C369 comp[61] NAND3_9/VDD 0.01934f
C370 NAND3_37/m1_n11242_6204# comp[25] 0.01965f
C371 wl[16] NAND3_9/VDD 0.03446f
C372 comp[26] NAND3_9/VDD 0.01576f
C373 wl[48] NAND3_9/VDD 0.03446f
C374 NAND3_23/m1_n10970_6203# NAND3_9/VDD 0.07502f
C375 wl[28] NAND3_9/VDD 0.03446f
C376 NAND3_49/m1_n11242_6204# NAND3_50/m1_n11242_6204# 0.01033f
C377 wl[38] NAND3_9/VDD 0.03446f
C378 NAND3_34/m1_n11242_6204# NAND3_9/VDD 0.01389f
C379 comp[12] NAND3_51/m1_n11242_6204# 0.04042f
C380 NAND3_9/VDD wl[60] 0.03446f
C381 NAND3_9/m1_n11242_6204# NAND3_8/m1_n11242_6204# 0.02886f
C382 wl[15] NAND3_9/VDD 0.03446f
C383 comp[48] NAND3_9/VDD 0.15022f
C384 NAND3_13/m1_n10970_6203# NAND3_14/m1_n10970_6203# 0.04082f
C385 comp[12] comp[10] 0.26719f
C386 NAND3_40/m1_n10970_6203# NAND3_41/m1_n10970_6203# 0.09992f
C387 NAND3_36/m1_n11242_6204# comp[25] 0.01768f
C388 wl[13] NAND3_9/VDD 0.03446f
C389 NAND3_49/m1_n10970_6203# NAND3_9/VDD 0.07502f
C390 NAND3_19/m1_n11242_6204# NAND3_9/VDD 0.01389f
C391 comp[57] comp[58] 0.90907f
C392 NAND3_27/m1_n10970_6203# NAND3_26/m1_n10970_6203# 0.09992f
C393 comp[61] comp[60] 1.16908f
C394 comp[48] comp[50] 0.05611f
C395 comp[4] NAND3_57/m1_n11242_6204# 0.03186f
C396 comp[7] comp[6] 1.16907f
C397 comp[19] NAND3_9/VDD 0.02071f
C398 NAND3_5/m1_n11242_6204# NAND3_9/VDD 0.01389f
C399 NAND3_32/m1_n11242_6204# NAND3_31/m1_n11242_6204# 0.01033f
C400 NAND3_17/m1_n10970_6203# NAND3_18/m1_n10970_6203# 0.04082f
C401 comp[3] NAND3_9/VDD 0.15022f
C402 NAND3_25/m1_n11242_6204# comp[36] 0.05586f
C403 comp[19] NAND3_42/m1_n11242_6204# 0.01768f
C404 comp[49] NAND3_9/VDD 0.02071f
C405 comp[23] NAND3_9/VDD 0.01576f
C406 comp[34] NAND3_9/VDD 0.09775f
C407 NAND3_25/m1_n11242_6204# comp[37] 0.01965f
C408 comp[49] comp[50] 0.98258f
C409 NAND3_9/VDD wl[17] 0.03446f
C410 NAND3_15/m1_n11242_6204# NAND3_14/m1_n11242_6204# 0.02886f
C411 comp[54] NAND3_7/m1_n11242_6204# 0.05586f
C412 comp[2] comp[3] 0.53753f
C413 NAND3_60/m1_n11242_6204# NAND3_9/VDD 0.01389f
C414 NAND3_46/m1_n10970_6203# NAND3_9/VDD 0.07502f
C415 NAND3_9/VDD wl[24] 0.03446f
C416 NAND3_28/m1_n11242_6204# NAND3_9/VDD 0.01389f
C417 NAND3_50/m1_n11242_6204# NAND3_9/VDD 0.01389f
C418 comp[9] NAND3_54/m1_n11242_6204# 0.04688f
C419 NAND3_40/m1_n10970_6203# NAND3_9/VDD 0.07502f
C420 NAND3_9/VDD comp[44] 0.01576f
C421 NAND3_12/m1_n11242_6204# comp[51] 0.04688f
C422 comp[47] NAND3_9/VDD 0.01576f
C423 NAND3_48/m1_n11242_6204# NAND3_47/m1_n11242_6204# 0.01033f
C424 comp[29] comp[31] 0.02007f
C425 NAND3_23/m1_n10970_6203# NAND3_22/m1_n10970_6203# 0.09992f
C426 wl[4] NAND3_9/VDD 0.03446f
C427 NAND3_9/VDD NAND3_53/m1_n11242_6204# 0.01389f
C428 NAND3_9/VDD NAND3_51/m1_n11242_6204# 0.01389f
C429 comp[19] comp[18] 1.16908f
C430 comp[24] NAND3_9/VDD 0.15022f
C431 wl[35] NAND3_9/VDD 0.03446f
C432 wl[11] NAND3_9/VDD 0.03446f
C433 comp[33] NAND3_29/m1_n11242_6204# 0.07714f
C434 comp[10] NAND3_9/VDD 0.09775f
C435 comp[36] NAND3_9/VDD 0.15022f
C436 comp[27] comp[26] 0.53753f
C437 comp[37] NAND3_9/VDD 0.02071f
C438 wl[26] NAND3_9/VDD 0.03446f
C439 comp[27] NAND3_34/m1_n11242_6204# 0.0227f
C440 NAND3_27/m1_n11242_6204# comp[34] 0.03186f
C441 wl[43] NAND3_9/VDD 0.03446f
C442 comp[6] NAND3_9/VDD 0.15022f
C443 NAND3_16/m1_n11242_6204# NAND3_15/m1_n11242_6204# 0.01033f
C444 NAND3_56/m1_n10970_6203# NAND3_9/VDD 0.07502f
C445 NAND3_49/m1_n11242_6204# NAND3_48/m1_n11242_6204# 0.02886f
C446 NAND3_62/m1_n10970_6203# NAND3_61/m1_n10970_6203# 0.04082f
C447 NAND3_19/m1_n11242_6204# NAND3_18/m1_n11242_6204# 0.02886f
C448 NAND3_17/m1_n10970_6203# NAND3_16/m1_n10970_6203# 0.09992f
C449 NAND3_37/m1_n10970_6203# NAND3_9/VDD 0.07502f
C450 comp[29] NAND3_9/VDD 0.01576f
C451 NAND3_59/m1_n10970_6203# NAND3_9/VDD 0.07502f
C452 NAND3_34/m1_n10970_6203# NAND3_33/m1_n10970_6203# 0.04082f
C453 NAND3_28/m1_n10970_6203# NAND3_9/VDD 0.07502f
C454 NAND3_21/m1_n10970_6203# NAND3_20/m1_n10970_6203# 0.09992f
C455 NAND3_27/m1_n11242_6204# NAND3_28/m1_n11242_6204# 0.01033f
C456 wl[41] NAND3_9/VDD 0.03446f
C457 wl[5] NAND3_9/VDD 0.03446f
C458 NAND3_48/m1_n11242_6204# comp[13] 0.01768f
C459 NAND3_17/m1_n10970_6203# NAND3_9/VDD 0.07502f
C460 NAND3_57/m1_n10970_6203# NAND3_56/m1_n10970_6203# 0.09992f
C461 NAND3_5/m1_n11242_6204# NAND3_4/m1_n11242_6204# 0.02886f
C462 comp[48] NAND3_14/m1_n11242_6204# 0.07767f
C463 NAND3_1/m1_n10970_6203# NAND3_0/m1_n10970_6203# 0.09992f
C464 NAND3_17/m1_n11242_6204# comp[45] 0.07714f
C465 comp[26] comp[28] 0.25793f
C466 NAND3_38/m1_n10970_6203# NAND3_39/m1_n10970_6203# 0.09992f
C467 NAND3_12/m1_n10970_6203# NAND3_9/VDD 0.07502f
C468 NAND3_34/m1_n11242_6204# comp[28] 0.04563f
C469 NAND3_20/m1_n10970_6203# NAND3_19/m1_n10970_6203# 0.04082f
C470 NAND3_39/m1_n11242_6204# NAND3_40/m1_n11242_6204# 0.01033f
C471 comp[36] NAND3_27/m1_n11242_6204# 0.04042f
C472 NAND3_56/m1_n11242_6204# comp[6] 0.07767f
C473 wl[51] NAND3_9/VDD 0.03446f
C474 comp[0] NAND3_9/VDD 0.14885f
C475 NAND3_9/VDD NAND3_53/m1_n10970_6203# 0.07502f
C476 NAND3_9/VDD NAND3_3/m1_n10970_6203# 0.07502f
C477 NAND3_48/m1_n11242_6204# NAND3_9/VDD 0.01389f
C478 NAND3_57/m1_n11242_6204# NAND3_58/m1_n11242_6204# 0.01033f
C479 NAND3_33/m1_n11242_6204# comp[30] 0.04042f
C480 comp[22] NAND3_40/m1_n11242_6204# 0.04563f
C481 comp[2] comp[0] 0.05611f
C482 NAND3_43/m1_n11242_6204# NAND3_9/VDD 0.01389f
C483 NAND3_49/m1_n10970_6203# NAND3_50/m1_n10970_6203# 0.04082f
C484 NAND3_35/m1_n10970_6203# NAND3_9/VDD 0.07502f
C485 NAND3_59/m1_n11242_6204# NAND3_58/m1_n11242_6204# 0.02886f
C486 comp[40] NAND3_22/m1_n11242_6204# 0.04563f
C487 comp[24] NAND3_38/m1_n11242_6204# 0.07767f
C488 NAND3_27/m1_n10970_6203# NAND3_28/m1_n10970_6203# 0.04082f
C489 NAND3_43/m1_n11242_6204# NAND3_42/m1_n11242_6204# 0.02886f
C490 NAND3_19/m1_n11242_6204# comp[43] 0.01965f
C491 comp[59] NAND3_9/VDD 0.01576f
C492 NAND3_30/m1_n11242_6204# comp[31] 0.01768f
C493 NAND3_33/m1_n10970_6203# NAND3_32/m1_n10970_6203# 0.09992f
C494 NAND3_9/VDD wl[32] 0.03446f
C495 wl[50] NAND3_9/VDD 0.03446f
C496 NAND3_9/VDD comp[20] 0.01576f
C497 NAND3_37/m1_n11242_6204# NAND3_9/VDD 0.01389f
C498 comp[21] comp[20] 0.53753f
C499 NAND3_39/m1_n11242_6204# NAND3_9/VDD 0.01389f
C500 wl[59] NAND3_9/VDD 0.03446f
C501 NAND3_62/m1_n11242_6204# NAND3_61/m1_n11242_6204# 0.01033f
C502 NAND3_13/m1_n10970_6203# NAND3_9/VDD 0.07502f
C503 NAND3_1/m1_n11242_6204# NAND3_0/m1_n11242_6204# 0.02886f
C504 NAND3_1/m1_n11242_6204# comp[61] 0.01965f
C505 NAND3_9/VDD NAND3_52/m1_n10970_6203# 0.07502f
C506 comp[12] comp[11] 0.48492f
C507 NAND3_9/VDD comp[51] 0.15022f
C508 NAND3_9/VDD NAND3_36/m1_n11242_6204# 0.01389f
C509 NAND3_18/m1_n10970_6203# NAND3_19/m1_n10970_6203# 0.09992f
C510 comp[59] comp[60] 0.48492f
C511 NAND3_58/m1_n10970_6203# NAND3_9/VDD 0.07502f
C512 NAND3_30/m1_n11242_6204# NAND3_9/VDD 0.01389f
C513 NAND3_43/m1_n11242_6204# comp[18] 0.05586f
C514 comp[17] comp[16] 1.23267f
C515 comp[51] comp[50] 0.53753f
C516 comp[22] NAND3_9/VDD 0.09775f
C517 wl[23] NAND3_9/VDD 0.03446f
C518 comp[22] comp[21] 0.90907f
C519 comp[44] comp[43] 0.98258f
C520 comp[57] NAND3_5/m1_n11242_6204# 0.07714f
C521 NAND3_55/m1_n10970_6203# NAND3_9/VDD 0.07502f
C522 comp[4] NAND3_9/VDD 0.09775f
C523 NAND3_58/m1_n10970_6203# NAND3_57/m1_n10970_6203# 0.04082f
C524 comp[29] comp[28] 1.23267f
C525 comp[18] comp[20] 0.05611f
C526 comp[9] NAND3_53/m1_n11242_6204# 0.07714f
C527 comp[13] comp[11] 0.02007f
C528 NAND3_51/m1_n10970_6203# NAND3_52/m1_n10970_6203# 0.04082f
C529 NAND3_47/m1_n10970_6203# NAND3_46/m1_n10970_6203# 0.09992f
C530 comp[10] comp[9] 0.90907f
C531 comp[4] comp[2] 0.25793f
C532 wl[40] NAND3_9/VDD 0.03446f
C533 NAND3_9/VDD comp[45] 0.15022f
C534 NAND3_28/m1_n10970_6203# NAND3_29/m1_n10970_6203# 0.09992f
C535 wl[8] NAND3_9/VDD 0.03446f
C536 comp[7] comp[5] 0.02007f
C537 wl[61] NAND3_9/VDD 0.03446f
C538 NAND3_44/m1_n11242_6204# NAND3_43/m1_n11242_6204# 0.01033f
C539 NAND3_34/m1_n10970_6203# NAND3_9/VDD 0.07502f
C540 comp[17] NAND3_9/VDD 0.01576f
C541 NAND3_2/m1_n11242_6204# NAND3_9/VDD 0.01389f
C542 NAND3_42/m1_n10970_6203# NAND3_43/m1_n10970_6203# 0.09992f
C543 NAND3_9/VDD NAND3_21/m1_n10970_6203# 0.07502f
C544 wl[25] NAND3_9/VDD 0.03446f
C545 wl[46] NAND3_9/VDD 0.03446f
C546 NAND3_15/m1_n11242_6204# comp[48] 0.04042f
C547 NAND3_32/m1_n10970_6203# NAND3_31/m1_n10970_6203# 0.04082f
C548 comp[51] comp[52] 0.90907f
C549 wl[29] NAND3_9/VDD 0.03446f
C550 NAND3_9/m1_n11242_6204# NAND3_9/VDD 0.01389f
C551 NAND3_9/VDD comp[11] 0.01576f
C552 comp[39] NAND3_22/m1_n11242_6204# 0.0227f
C553 NAND3_11/m1_n11242_6204# comp[51] 0.07714f
C554 NAND3_23/m1_n11242_6204# NAND3_22/m1_n11242_6204# 0.02886f
C555 comp[7] comp[8] 0.98258f
C556 NAND3_9/VDD NAND3_52/m1_n11242_6204# 0.01389f
C557 NAND3_37/m1_n11242_6204# NAND3_38/m1_n11242_6204# 0.01033f
C558 NAND3_39/m1_n11242_6204# NAND3_38/m1_n11242_6204# 0.02886f
C559 NAND3_9/VDD NAND3_19/m1_n10970_6203# 0.07502f
C560 comp[46] NAND3_9/VDD 0.09775f
C561 comp[61] NAND3_0/m1_n11242_6204# 0.01768f
C562 NAND3_54/m1_n11242_6204# NAND3_53/m1_n11242_6204# 0.01033f
C563 NAND3_36/m1_n10970_6203# NAND3_9/VDD 0.07502f
C564 comp[33] comp[32] 0.53753f
C565 comp[42] NAND3_20/m1_n11242_6204# 0.07767f
C566 NAND3_2/m1_n11242_6204# comp[60] 0.07767f
C567 comp[27] NAND3_36/m1_n11242_6204# 0.04688f
C568 comp[41] comp[40] 1.23267f
C569 comp[37] NAND3_24/m1_n11242_6204# 0.01768f
C570 comp[59] comp[58] 1.23267f
C571 comp[17] comp[18] 0.48492f
C572 comp[30] comp[32] 0.05611f
C573 comp[5] NAND3_9/VDD 0.01576f
C574 wl[14] NAND3_9/VDD 0.03446f
C575 NAND3_55/m1_n11242_6204# comp[7] 0.01965f
C576 NAND3_41/m1_n10970_6203# NAND3_42/m1_n10970_6203# 0.04082f
C577 NAND3_61/m1_n11242_6204# NAND3_60/m1_n11242_6204# 0.02886f
C578 NAND3_18/m1_n11242_6204# comp[45] 0.04688f
C579 NAND3_32/m1_n10970_6203# NAND3_9/VDD 0.07502f
C580 comp[51] NAND3_10/m1_n11242_6204# 0.0227f
C581 wl[56] NAND3_9/VDD 0.03446f
C582 wl[43] VSUBS -0.16248f
C583 NAND3_19/m1_n11242_6204# VSUBS -0.39903f
C584 comp[44] VSUBS 0.64134f
C585 NAND3_19/m1_n10970_6203# VSUBS -0.60233f
C586 NAND3_19/nfet_2/a_94_0# VSUBS -0.07213f
C587 NAND3_19/nfet_1/a_94_0# VSUBS -0.07213f
C588 wl[53] VSUBS -0.16248f
C589 NAND3_9/m1_n11242_6204# VSUBS -0.39903f
C590 comp[54] VSUBS -0.03413f
C591 NAND3_9/m1_n10970_6203# VSUBS -0.60233f
C592 NAND3_9/nfet_2/a_94_0# VSUBS -0.07213f
C593 NAND3_9/nfet_1/a_94_0# VSUBS -0.07213f
C594 wl[33] VSUBS -0.16248f
C595 NAND3_29/m1_n11242_6204# VSUBS -0.39903f
C596 comp[34] VSUBS 0.09777f
C597 NAND3_29/m1_n10970_6203# VSUBS -0.60233f
C598 NAND3_29/nfet_2/a_94_0# VSUBS -0.07213f
C599 NAND3_29/nfet_1/a_94_0# VSUBS -0.07213f
C600 wl[44] VSUBS -0.16248f
C601 NAND3_18/m1_n11242_6204# VSUBS -0.39903f
C602 comp[45] VSUBS -0.1522f
C603 NAND3_18/m1_n10970_6203# VSUBS -0.60233f
C604 NAND3_18/nfet_2/a_94_0# VSUBS -0.07213f
C605 NAND3_18/nfet_1/a_94_0# VSUBS -0.07213f
C606 wl[54] VSUBS -0.16248f
C607 NAND3_8/m1_n11242_6204# VSUBS -0.39903f
C608 comp[55] VSUBS 0.10346f
C609 NAND3_8/m1_n10970_6203# VSUBS -0.60233f
C610 NAND3_8/nfet_2/a_94_0# VSUBS -0.07213f
C611 NAND3_8/nfet_1/a_94_0# VSUBS -0.07213f
C612 wl[23] VSUBS -0.16248f
C613 NAND3_39/m1_n11242_6204# VSUBS -0.39903f
C614 comp[24] VSUBS -0.03413f
C615 NAND3_39/m1_n10970_6203# VSUBS -0.60233f
C616 NAND3_39/nfet_2/a_94_0# VSUBS -0.07213f
C617 NAND3_39/nfet_1/a_94_0# VSUBS -0.07213f
C618 wl[34] VSUBS -0.16248f
C619 NAND3_28/m1_n11242_6204# VSUBS -0.39903f
C620 comp[35] VSUBS 0.43712f
C621 NAND3_28/m1_n10970_6203# VSUBS -0.60233f
C622 NAND3_28/nfet_2/a_94_0# VSUBS -0.07213f
C623 NAND3_28/nfet_1/a_94_0# VSUBS -0.07213f
C624 wl[45] VSUBS -0.16248f
C625 NAND3_17/m1_n11242_6204# VSUBS -0.39903f
C626 comp[46] VSUBS 0.09777f
C627 NAND3_17/m1_n10970_6203# VSUBS -0.60233f
C628 NAND3_17/nfet_2/a_94_0# VSUBS -0.07213f
C629 NAND3_17/nfet_1/a_94_0# VSUBS -0.07213f
C630 wl[55] VSUBS -0.16248f
C631 NAND3_7/m1_n11242_6204# VSUBS -0.39903f
C632 comp[56] VSUBS 0.64134f
C633 NAND3_7/m1_n10970_6203# VSUBS -0.60233f
C634 NAND3_7/nfet_2/a_94_0# VSUBS -0.07213f
C635 NAND3_7/nfet_1/a_94_0# VSUBS -0.07213f
C636 wl[13] VSUBS -0.16248f
C637 NAND3_49/m1_n11242_6204# VSUBS -0.39903f
C638 comp[14] VSUBS 0.64134f
C639 NAND3_49/m1_n10970_6203# VSUBS -0.60233f
C640 NAND3_49/nfet_2/a_94_0# VSUBS -0.07213f
C641 NAND3_49/nfet_1/a_94_0# VSUBS -0.07213f
C642 wl[24] VSUBS -0.16248f
C643 NAND3_38/m1_n11242_6204# VSUBS -0.39903f
C644 comp[25] VSUBS 0.10346f
C645 NAND3_38/m1_n10970_6203# VSUBS -0.60233f
C646 NAND3_38/nfet_2/a_94_0# VSUBS -0.07213f
C647 NAND3_38/nfet_1/a_94_0# VSUBS -0.07213f
C648 wl[35] VSUBS -0.16248f
C649 NAND3_27/m1_n11242_6204# VSUBS -0.39903f
C650 comp[36] VSUBS -0.03413f
C651 NAND3_27/m1_n10970_6203# VSUBS -0.60233f
C652 NAND3_27/nfet_2/a_94_0# VSUBS -0.07213f
C653 NAND3_27/nfet_1/a_94_0# VSUBS -0.07213f
C654 wl[46] VSUBS -0.16248f
C655 NAND3_16/m1_n11242_6204# VSUBS -0.39903f
C656 comp[47] VSUBS 0.43712f
C657 NAND3_16/m1_n10970_6203# VSUBS -0.60233f
C658 NAND3_16/nfet_2/a_94_0# VSUBS -0.07213f
C659 NAND3_16/nfet_1/a_94_0# VSUBS -0.07213f
C660 wl[56] VSUBS -0.16248f
C661 NAND3_6/m1_n11242_6204# VSUBS -0.39903f
C662 comp[57] VSUBS -0.1522f
C663 NAND3_6/m1_n10970_6203# VSUBS -0.60233f
C664 NAND3_6/nfet_2/a_94_0# VSUBS -0.07213f
C665 NAND3_6/nfet_1/a_94_0# VSUBS -0.07213f
C666 wl[57] VSUBS -0.16248f
C667 NAND3_5/m1_n11242_6204# VSUBS -0.39903f
C668 comp[58] VSUBS 0.09777f
C669 NAND3_5/m1_n10970_6203# VSUBS -0.60233f
C670 NAND3_5/nfet_2/a_94_0# VSUBS -0.07213f
C671 NAND3_5/nfet_1/a_94_0# VSUBS -0.07213f
C672 wl[3] VSUBS -0.16248f
C673 NAND3_59/m1_n11242_6204# VSUBS -0.39903f
C674 comp[4] VSUBS 0.09777f
C675 NAND3_59/m1_n10970_6203# VSUBS -0.60233f
C676 NAND3_59/nfet_2/a_94_0# VSUBS -0.07213f
C677 NAND3_59/nfet_1/a_94_0# VSUBS -0.07213f
C678 wl[14] VSUBS -0.16248f
C679 NAND3_48/m1_n11242_6204# VSUBS -0.39903f
C680 comp[15] VSUBS -0.1522f
C681 NAND3_48/m1_n10970_6203# VSUBS -0.60233f
C682 NAND3_48/nfet_2/a_94_0# VSUBS -0.07213f
C683 NAND3_48/nfet_1/a_94_0# VSUBS -0.07213f
C684 wl[25] VSUBS -0.16248f
C685 NAND3_37/m1_n11242_6204# VSUBS -0.39903f
C686 comp[26] VSUBS 0.64134f
C687 NAND3_37/m1_n10970_6203# VSUBS -0.60233f
C688 NAND3_37/nfet_2/a_94_0# VSUBS -0.07213f
C689 NAND3_37/nfet_1/a_94_0# VSUBS -0.07213f
C690 wl[36] VSUBS -0.16248f
C691 NAND3_26/m1_n11242_6204# VSUBS -0.39903f
C692 comp[37] VSUBS 0.10346f
C693 NAND3_26/m1_n10970_6203# VSUBS -0.60233f
C694 NAND3_26/nfet_2/a_94_0# VSUBS -0.07213f
C695 NAND3_26/nfet_1/a_94_0# VSUBS -0.07213f
C696 wl[47] VSUBS -0.16248f
C697 NAND3_15/m1_n11242_6204# VSUBS -0.39903f
C698 comp[48] VSUBS -0.03413f
C699 NAND3_15/m1_n10970_6203# VSUBS -0.60233f
C700 NAND3_15/nfet_2/a_94_0# VSUBS -0.07213f
C701 NAND3_15/nfet_1/a_94_0# VSUBS -0.07213f
C702 wl[58] VSUBS -0.16248f
C703 NAND3_4/m1_n11242_6204# VSUBS -0.39903f
C704 comp[59] VSUBS 0.43712f
C705 NAND3_4/m1_n10970_6203# VSUBS -0.60233f
C706 NAND3_4/nfet_2/a_94_0# VSUBS -0.07213f
C707 NAND3_4/nfet_1/a_94_0# VSUBS -0.07213f
C708 wl[4] VSUBS -0.16248f
C709 NAND3_58/m1_n11242_6204# VSUBS -0.39903f
C710 comp[5] VSUBS 0.43712f
C711 NAND3_58/m1_n10970_6203# VSUBS -0.60233f
C712 NAND3_58/nfet_2/a_94_0# VSUBS -0.07213f
C713 NAND3_58/nfet_1/a_94_0# VSUBS -0.07213f
C714 wl[5] VSUBS -0.16248f
C715 NAND3_57/m1_n11242_6204# VSUBS -0.39903f
C716 comp[6] VSUBS -0.03413f
C717 NAND3_57/m1_n10970_6203# VSUBS -0.60233f
C718 NAND3_57/nfet_2/a_94_0# VSUBS -0.07213f
C719 NAND3_57/nfet_1/a_94_0# VSUBS -0.07213f
C720 wl[15] VSUBS -0.16248f
C721 NAND3_47/m1_n11242_6204# VSUBS -0.39903f
C722 comp[16] VSUBS 0.09777f
C723 NAND3_47/m1_n10970_6203# VSUBS -0.60233f
C724 NAND3_47/nfet_2/a_94_0# VSUBS -0.07213f
C725 NAND3_47/nfet_1/a_94_0# VSUBS -0.07213f
C726 wl[16] VSUBS -0.16248f
C727 NAND3_46/m1_n11242_6204# VSUBS -0.39903f
C728 comp[17] VSUBS 0.43712f
C729 NAND3_46/m1_n10970_6203# VSUBS -0.60233f
C730 NAND3_46/nfet_2/a_94_0# VSUBS -0.07213f
C731 NAND3_46/nfet_1/a_94_0# VSUBS -0.07213f
C732 wl[26] VSUBS -0.16248f
C733 NAND3_36/m1_n11242_6204# VSUBS -0.39903f
C734 comp[27] VSUBS -0.1522f
C735 NAND3_36/m1_n10970_6203# VSUBS -0.60233f
C736 NAND3_36/nfet_2/a_94_0# VSUBS -0.07213f
C737 NAND3_36/nfet_1/a_94_0# VSUBS -0.07213f
C738 wl[27] VSUBS -0.16248f
C739 NAND3_35/m1_n11242_6204# VSUBS -0.39903f
C740 comp[28] VSUBS 0.09777f
C741 NAND3_35/m1_n10970_6203# VSUBS -0.60233f
C742 NAND3_35/nfet_2/a_94_0# VSUBS -0.07213f
C743 NAND3_35/nfet_1/a_94_0# VSUBS -0.07213f
C744 wl[37] VSUBS -0.16248f
C745 NAND3_25/m1_n11242_6204# VSUBS -0.39903f
C746 comp[38] VSUBS 0.64133f
C747 NAND3_25/m1_n10970_6203# VSUBS -0.60233f
C748 NAND3_25/nfet_2/a_94_0# VSUBS -0.07213f
C749 NAND3_25/nfet_1/a_94_0# VSUBS -0.07213f
C750 wl[38] VSUBS -0.16248f
C751 NAND3_24/m1_n11242_6204# VSUBS -0.39903f
C752 comp[39] VSUBS -0.1522f
C753 NAND3_24/m1_n10970_6203# VSUBS -0.60233f
C754 NAND3_24/nfet_2/a_94_0# VSUBS -0.07213f
C755 NAND3_24/nfet_1/a_94_0# VSUBS -0.07213f
C756 wl[48] VSUBS -0.16248f
C757 NAND3_14/m1_n11242_6204# VSUBS -0.39903f
C758 comp[49] VSUBS 0.10346f
C759 NAND3_14/m1_n10970_6203# VSUBS -0.60233f
C760 NAND3_14/nfet_2/a_94_0# VSUBS -0.07213f
C761 NAND3_14/nfet_1/a_94_0# VSUBS -0.07213f
C762 wl[49] VSUBS -0.16248f
C763 NAND3_13/m1_n11242_6204# VSUBS -0.39903f
C764 comp[50] VSUBS 0.64134f
C765 NAND3_13/m1_n10970_6203# VSUBS -0.60233f
C766 NAND3_13/nfet_2/a_94_0# VSUBS -0.07213f
C767 NAND3_13/nfet_1/a_94_0# VSUBS -0.07213f
C768 wl[59] VSUBS -0.16248f
C769 NAND3_3/m1_n11242_6204# VSUBS -0.39903f
C770 comp[60] VSUBS -0.03053f
C771 NAND3_3/m1_n10970_6203# VSUBS -0.60233f
C772 NAND3_3/nfet_2/a_94_0# VSUBS -0.07213f
C773 NAND3_3/nfet_1/a_94_0# VSUBS -0.07213f
C774 wl[6] VSUBS -0.16248f
C775 NAND3_56/m1_n11242_6204# VSUBS -0.39903f
C776 comp[7] VSUBS 0.10346f
C777 NAND3_56/m1_n10970_6203# VSUBS -0.60233f
C778 NAND3_56/nfet_2/a_94_0# VSUBS -0.07213f
C779 NAND3_56/nfet_1/a_94_0# VSUBS -0.07213f
C780 wl[17] VSUBS -0.16248f
C781 NAND3_45/m1_n11242_6204# VSUBS -0.39903f
C782 comp[18] VSUBS -0.03413f
C783 NAND3_45/m1_n10970_6203# VSUBS -0.60233f
C784 NAND3_45/nfet_2/a_94_0# VSUBS -0.07213f
C785 NAND3_45/nfet_1/a_94_0# VSUBS -0.07213f
C786 wl[28] VSUBS -0.16248f
C787 NAND3_34/m1_n11242_6204# VSUBS -0.39903f
C788 comp[29] VSUBS 0.43712f
C789 NAND3_34/m1_n10970_6203# VSUBS -0.60233f
C790 NAND3_34/nfet_2/a_94_0# VSUBS -0.07213f
C791 NAND3_34/nfet_1/a_94_0# VSUBS -0.07213f
C792 wl[39] VSUBS -0.16248f
C793 NAND3_23/m1_n11242_6204# VSUBS -0.39903f
C794 comp[40] VSUBS 0.09777f
C795 NAND3_23/m1_n10970_6203# VSUBS -0.60233f
C796 NAND3_23/nfet_2/a_94_0# VSUBS -0.07213f
C797 NAND3_23/nfet_1/a_94_0# VSUBS -0.07213f
C798 wl[50] VSUBS -0.16248f
C799 NAND3_12/m1_n11242_6204# VSUBS -0.39903f
C800 comp[51] VSUBS -0.1522f
C801 NAND3_12/m1_n10970_6203# VSUBS -0.60233f
C802 NAND3_12/nfet_2/a_94_0# VSUBS -0.07213f
C803 NAND3_12/nfet_1/a_94_0# VSUBS -0.07213f
C804 wl[60] VSUBS -0.16248f
C805 NAND3_2/m1_n11242_6204# VSUBS -0.39903f
C806 comp[61] VSUBS 0.10663f
C807 NAND3_2/m1_n10970_6203# VSUBS -0.60233f
C808 NAND3_2/nfet_2/a_94_0# VSUBS -0.07213f
C809 NAND3_2/nfet_1/a_94_0# VSUBS -0.07213f
C810 wl[7] VSUBS -0.16248f
C811 NAND3_55/m1_n11242_6204# VSUBS -0.39903f
C812 comp[8] VSUBS 0.64134f
C813 NAND3_55/m1_n10970_6203# VSUBS -0.60233f
C814 NAND3_55/nfet_2/a_94_0# VSUBS -0.07213f
C815 NAND3_55/nfet_1/a_94_0# VSUBS -0.07213f
C816 wl[18] VSUBS -0.16248f
C817 NAND3_44/m1_n11242_6204# VSUBS -0.39903f
C818 comp[19] VSUBS 0.10346f
C819 NAND3_44/m1_n10970_6203# VSUBS -0.60233f
C820 NAND3_44/nfet_2/a_94_0# VSUBS -0.07213f
C821 NAND3_44/nfet_1/a_94_0# VSUBS -0.07213f
C822 wl[29] VSUBS -0.16248f
C823 NAND3_33/m1_n11242_6204# VSUBS -0.39903f
C824 comp[30] VSUBS -0.03413f
C825 NAND3_33/m1_n10970_6203# VSUBS -0.60233f
C826 NAND3_33/nfet_2/a_94_0# VSUBS -0.07213f
C827 NAND3_33/nfet_1/a_94_0# VSUBS -0.07213f
C828 wl[40] VSUBS -0.16248f
C829 NAND3_22/m1_n11242_6204# VSUBS -0.39903f
C830 comp[41] VSUBS 0.43712f
C831 NAND3_22/m1_n10970_6203# VSUBS -0.60233f
C832 NAND3_22/nfet_2/a_94_0# VSUBS -0.07213f
C833 NAND3_22/nfet_1/a_94_0# VSUBS -0.07213f
C834 wl[51] VSUBS -0.16248f
C835 NAND3_11/m1_n11242_6204# VSUBS -0.39903f
C836 comp[52] VSUBS 0.09777f
C837 NAND3_11/m1_n10970_6203# VSUBS -0.60233f
C838 NAND3_11/nfet_2/a_94_0# VSUBS -0.07213f
C839 NAND3_11/nfet_1/a_94_0# VSUBS -0.07213f
C840 wl[61] VSUBS -0.16248f
C841 NAND3_1/m1_n11242_6204# VSUBS -0.39903f
C842 comp[62] VSUBS 0.28388f
C843 NAND3_1/m1_n10970_6203# VSUBS -0.60233f
C844 NAND3_1/nfet_2/a_94_0# VSUBS -0.07213f
C845 NAND3_1/nfet_1/a_94_0# VSUBS -0.07213f
C846 wl[8] VSUBS -0.16248f
C847 NAND3_54/m1_n11242_6204# VSUBS -0.39903f
C848 comp[9] VSUBS -0.1522f
C849 NAND3_54/m1_n10970_6203# VSUBS -0.60233f
C850 NAND3_54/nfet_2/a_94_0# VSUBS -0.07213f
C851 NAND3_54/nfet_1/a_94_0# VSUBS -0.07213f
C852 wl[19] VSUBS -0.16248f
C853 NAND3_43/m1_n11242_6204# VSUBS -0.39903f
C854 comp[20] VSUBS 0.64134f
C855 NAND3_43/m1_n10970_6203# VSUBS -0.60233f
C856 NAND3_43/nfet_2/a_94_0# VSUBS -0.07213f
C857 NAND3_43/nfet_1/a_94_0# VSUBS -0.07213f
C858 wl[30] VSUBS -0.16248f
C859 NAND3_32/m1_n11242_6204# VSUBS -0.39903f
C860 comp[31] VSUBS 0.10346f
C861 NAND3_32/m1_n10970_6203# VSUBS -0.60233f
C862 NAND3_32/nfet_2/a_94_0# VSUBS -0.07213f
C863 NAND3_32/nfet_1/a_94_0# VSUBS -0.07213f
C864 wl[41] VSUBS -0.16248f
C865 NAND3_21/m1_n11242_6204# VSUBS -0.39903f
C866 comp[42] VSUBS -0.03413f
C867 NAND3_21/m1_n10970_6203# VSUBS -0.60233f
C868 NAND3_21/nfet_2/a_94_0# VSUBS -0.07213f
C869 NAND3_21/nfet_1/a_94_0# VSUBS -0.07213f
C870 wl[52] VSUBS -0.16248f
C871 NAND3_10/m1_n11242_6204# VSUBS -0.39903f
C872 comp[53] VSUBS 0.43712f
C873 NAND3_10/m1_n10970_6203# VSUBS -0.60233f
C874 NAND3_10/nfet_2/a_94_0# VSUBS -0.07213f
C875 NAND3_10/nfet_1/a_94_0# VSUBS -0.07213f
C876 wl[62] VSUBS -0.14056f
C877 NAND3_0/m1_n11242_6204# VSUBS -0.39903f
C878 GND VSUBS -0.17931f
C879 NAND3_0/m1_n10970_6203# VSUBS -0.60233f
C880 NAND3_0/nfet_2/a_94_0# VSUBS -0.07213f
C881 NAND3_0/nfet_1/a_94_0# VSUBS -0.07213f
C882 wl[9] VSUBS -0.16248f
C883 NAND3_53/m1_n11242_6204# VSUBS -0.39903f
C884 comp[10] VSUBS 0.09777f
C885 NAND3_53/m1_n10970_6203# VSUBS -0.60233f
C886 NAND3_53/nfet_2/a_94_0# VSUBS -0.07213f
C887 NAND3_53/nfet_1/a_94_0# VSUBS -0.07213f
C888 wl[20] VSUBS -0.16248f
C889 NAND3_42/m1_n11242_6204# VSUBS -0.39903f
C890 comp[21] VSUBS -0.1522f
C891 NAND3_42/m1_n10970_6203# VSUBS -0.60233f
C892 NAND3_42/nfet_2/a_94_0# VSUBS -0.07213f
C893 NAND3_42/nfet_1/a_94_0# VSUBS -0.07213f
C894 wl[31] VSUBS -0.16248f
C895 NAND3_31/m1_n11242_6204# VSUBS -0.39903f
C896 comp[32] VSUBS 0.64134f
C897 NAND3_31/m1_n10970_6203# VSUBS -0.60233f
C898 NAND3_31/nfet_2/a_94_0# VSUBS -0.07213f
C899 NAND3_31/nfet_1/a_94_0# VSUBS -0.07213f
C900 wl[42] VSUBS -0.16248f
C901 NAND3_20/m1_n11242_6204# VSUBS -0.39903f
C902 comp[43] VSUBS 0.10346f
C903 NAND3_20/m1_n10970_6203# VSUBS -0.60233f
C904 NAND3_20/nfet_2/a_94_0# VSUBS -0.07213f
C905 NAND3_20/nfet_1/a_94_0# VSUBS -0.07213f
C906 wl[10] VSUBS -0.16248f
C907 NAND3_52/m1_n11242_6204# VSUBS -0.39903f
C908 comp[11] VSUBS 0.43712f
C909 NAND3_52/m1_n10970_6203# VSUBS -0.60233f
C910 NAND3_52/nfet_2/a_94_0# VSUBS -0.07213f
C911 NAND3_52/nfet_1/a_94_0# VSUBS -0.07213f
C912 wl[21] VSUBS -0.16248f
C913 NAND3_41/m1_n11242_6204# VSUBS -0.39903f
C914 comp[22] VSUBS 0.09777f
C915 NAND3_41/m1_n10970_6203# VSUBS -0.60233f
C916 NAND3_41/nfet_2/a_94_0# VSUBS -0.07213f
C917 NAND3_41/nfet_1/a_94_0# VSUBS -0.07213f
C918 wl[32] VSUBS -0.16248f
C919 NAND3_30/m1_n11242_6204# VSUBS -0.39903f
C920 comp[33] VSUBS -0.1522f
C921 NAND3_30/m1_n10970_6203# VSUBS -0.60233f
C922 NAND3_30/nfet_2/a_94_0# VSUBS -0.07213f
C923 NAND3_30/nfet_1/a_94_0# VSUBS -0.07213f
C924 wl[0] VSUBS -0.15144f
C925 NAND3_9/VDD VSUBS -0.10916p
C926 NAND3_62/m1_n11242_6204# VSUBS -0.40408f
C927 comp[1] VSUBS 0.1243f
C928 NAND3_62/m1_n10970_6203# VSUBS -0.62193f
C929 VDD VSUBS -0.12188f
C930 NAND3_62/nfet_2/a_94_0# VSUBS -0.07213f
C931 comp[0] VSUBS -0.16262f
C932 NAND3_62/nfet_1/a_94_0# VSUBS -0.07213f
C933 wl[11] VSUBS -0.16248f
C934 NAND3_51/m1_n11242_6204# VSUBS -0.39903f
C935 comp[12] VSUBS -0.03413f
C936 NAND3_51/m1_n10970_6203# VSUBS -0.60233f
C937 NAND3_51/nfet_2/a_94_0# VSUBS -0.07213f
C938 NAND3_51/nfet_1/a_94_0# VSUBS -0.07213f
C939 wl[22] VSUBS -0.16248f
C940 NAND3_40/m1_n11242_6204# VSUBS -0.39903f
C941 comp[23] VSUBS 0.43712f
C942 NAND3_40/m1_n10970_6203# VSUBS -0.60233f
C943 NAND3_40/nfet_2/a_94_0# VSUBS -0.07213f
C944 NAND3_40/nfet_1/a_94_0# VSUBS -0.07213f
C945 wl[1] VSUBS -0.16248f
C946 NAND3_61/m1_n11242_6204# VSUBS -0.39903f
C947 comp[2] VSUBS 0.64134f
C948 NAND3_61/m1_n10970_6203# VSUBS -0.60233f
C949 NAND3_61/nfet_2/a_94_0# VSUBS -0.07213f
C950 NAND3_61/nfet_1/a_94_0# VSUBS -0.07213f
C951 wl[12] VSUBS -0.16248f
C952 NAND3_50/m1_n11242_6204# VSUBS -0.39903f
C953 comp[13] VSUBS 0.10346f
C954 NAND3_50/m1_n10970_6203# VSUBS -0.60233f
C955 NAND3_50/nfet_2/a_94_0# VSUBS -0.07213f
C956 NAND3_50/nfet_1/a_94_0# VSUBS -0.07213f
C957 wl[2] VSUBS -0.16248f
C958 NAND3_60/m1_n11242_6204# VSUBS -0.39903f
C959 comp[3] VSUBS -0.1522f
C960 NAND3_60/m1_n10970_6203# VSUBS -0.60233f
C961 NAND3_60/nfet_2/a_94_0# VSUBS -0.07213f
C962 NAND3_60/nfet_1/a_94_0# VSUBS -0.07213f
.ends
