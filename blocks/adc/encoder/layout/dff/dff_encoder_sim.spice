* SPICE3 file created from dff_encoder_flat.ext - technology: gf180mcuD

.option scale=5n

.subckt dff_encoder VDD RST CLK D Q GND
X0 a_2331_1572# a_1717_365# VDD VDD pfet_03v3 ad=22.88n pd=0.612m as=14.784n ps=0.344m w=176 l=56
X1 VDD RST a_1717_365# VDD pfet_03v3 ad=14.784n pd=0.344m as=22.88n ps=0.612m w=176 l=56
X2 a_2332_365# a_1717_365# GND GND nfet_03v3 ad=5.928n pd=0.236m as=9.12n ps=0.396m w=72 l=56
X3 GND D a_1020_1572# GND nfet_03v3 ad=5.928n pd=0.236m as=9.12n ps=0.396m w=72 l=56
X4 a_2331_1572# CLK a_2332_365# GND nfet_03v3 ad=9.12n pd=0.396m as=5.928n ps=0.236m w=72 l=56
X5 a_1501_365# CLK GND GND nfet_03v3 ad=5.928n pd=0.236m as=5.928n ps=0.236m w=72 l=56
X6 a_1020_1572# CLK a_796_1572# VDD pfet_03v3 ad=22.88n pd=0.612m as=14.784n ps=0.344m w=176 l=56
X7 Q a_2331_1572# GND GND nfet_03v3 ad=21.472n pd=0.596m as=21.472n ps=0.596m w=176 l=56
X8 a_796_1572# D VDD VDD pfet_03v3 ad=14.784n pd=0.344m as=22.88n ps=0.612m w=176 l=56
X9 a_1717_365# a_1020_1572# a_1501_365# GND nfet_03v3 ad=9.12n pd=0.396m as=5.928n ps=0.236m w=72 l=56
X10 a_1717_365# a_1020_1572# a_1500_1572# VDD pfet_03v3 ad=22.88n pd=0.612m as=14.784n ps=0.344m w=176 l=56
X11 Q a_2331_1572# VDD VDD pfet_03v3 ad=45.76n pd=0.964m as=45.76n ps=0.964m w=352 l=56
X12 a_1500_1572# CLK VDD VDD pfet_03v3 ad=14.784n pd=0.344m as=22.88n ps=0.612m w=176 l=56
C0 a_1020_1572# a_1500_1572# 0.02186f
C1 D CLK 0.21441f
C2 VDD D 0.18382f
C3 a_1020_1572# RST 0.23982f
C4 a_1717_365# a_1500_1572# 0.02732f
C5 VDD CLK 0.41055f
C6 a_1020_1572# D 0.19888f
C7 a_2331_1572# CLK 0.07911f
C8 Q VDD 0.45114f
C9 a_2331_1572# VDD 0.59161f
C10 RST a_1717_365# 0.65924f
C11 a_1020_1572# CLK 0.48017f
C12 a_1020_1572# VDD 0.43863f
C13 VDD a_796_1572# 0.07684f
C14 a_2331_1572# Q 0.14426f
C15 a_2331_1572# a_2332_365# 0.03221f
C16 a_1501_365# a_1717_365# 0.02941f
C17 a_1717_365# CLK 0.23927f
C18 VDD a_1717_365# 0.41523f
C19 a_1020_1572# a_796_1572# 0.02693f
C20 a_2331_1572# a_1717_365# 0.1618f
C21 RST D 0.344f
C22 VDD a_1500_1572# 0.07618f
C23 a_1020_1572# a_1717_365# 0.33987f
C24 RST a_1501_365# 0.0153f
C25 RST CLK 0.16324f
C26 RST VDD 0.19248f
C27 Q GND 0.62812f
C28 RST GND 0.62279f
C29 CLK GND 1.40506f
C30 D GND 0.76777f
C31 VDD GND 4.91047f
C32 a_2332_365# GND 0.12719f
C33 a_1501_365# GND 0.12098f
C34 a_2331_1572# GND 0.81291f
C35 a_1717_365# GND 0.77515f
C36 a_1020_1572# GND 0.97163f
.ends
