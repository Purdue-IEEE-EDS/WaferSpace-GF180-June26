* SPICE3 file created from dff_encoder_flat2.ext - technology: gf180mcuD

.option scale=5n

.subckt dff_encoder VDD RST CLK D Q GND
X0 XM10_D XM7_D XM8_D VDD pfet_03v3 ad=22.88n pd=0.612m as=22.88n ps=0.612m w=176 l=56
X1 VDD XM21_D Q VDD pfet_03v3 ad=45.76n pd=0.964m as=45.76n ps=0.964m w=352 l=56
X2 GND XM21_D Q GND nfet_03v3 ad=21.472n pd=0.596m as=21.472n ps=0.596m w=176 l=56
X3 XM7_S CLK XM7_D VDD pfet_03v3 ad=22.88n pd=0.612m as=22.88n ps=0.612m w=176 l=56
X4 GND D XM7_D GND nfet_03v3 ad=9.12n pd=0.396m as=9.12n ps=0.396m w=72 l=56
X5 XM21_S CLK XM21_D GND nfet_03v3 ad=9.12n pd=0.396m as=9.12n ps=0.396m w=72 l=56
X6 VDD RST XM10_D VDD pfet_03v3 ad=14.784n pd=0.344m as=22.88n ps=0.612m w=176 l=56
X7 XM10_D XM7_D XM26_D GND nfet_03v3 ad=9.12n pd=0.396m as=9.12n ps=0.396m w=72 l=56
X8 XM7_S D VDD VDD pfet_03v3 ad=22.88n pd=0.612m as=22.88n ps=0.612m w=176 l=56
X9 XM21_D XM10_D VDD VDD pfet_03v3 ad=22.88n pd=0.612m as=14.784n ps=0.344m w=176 l=56
X10 XM26_D CLK GND GND nfet_03v3 ad=9.12n pd=0.396m as=9.12n ps=0.396m w=72 l=56
X11 GND XM10_D XM21_S GND nfet_03v3 ad=9.12n pd=0.396m as=9.12n ps=0.396m w=72 l=56
X12 XM8_D CLK VDD VDD pfet_03v3 ad=22.88n pd=0.612m as=22.88n ps=0.612m w=176 l=56
C0 Q XM10_D 0.0109f
C1 XM26_D RST 0.0195f
C2 XM26_D VDD 0.01114f
C3 XM26_D D 0.05091f
C4 CLK XM21_D 0.01563f
C5 XM21_D XM21_S 0.70132f
C6 CLK RST 0.04819f
C7 CLK VDD 0.27343f
C8 CLK D 0.24282f
C9 XM26_D XM10_D 0.02958f
C10 D XM21_S 0.02218f
C11 XM26_D XM7_D 0.09503f
C12 XM8_D VDD 0.59772f
C13 XM21_D VDD 0.28049f
C14 XM26_D XM7_S 0.026f
C15 D XM21_D 0.02092f
C16 XM21_S XM10_D 0.11882f
C17 CLK XM7_D 0.21748f
C18 RST VDD 0.19578f
C19 XM21_S XM7_D 0.03187f
C20 D RST 1.10804f
C21 D VDD 0.12308f
C22 XM8_D XM10_D 0.0329f
C23 XM8_D XM7_D 0.04018f
C24 CLK XM7_S 0.04168f
C25 XM21_D XM10_D 0.20642f
C26 RST XM10_D 0.6096f
C27 VDD XM10_D 0.2845f
C28 XM7_D RST 1.37685f
C29 XM7_S XM8_D 0.28064f
C30 XM7_D VDD 0.29321f
C31 D XM7_D 0.37712f
C32 XM7_S VDD 0.40022f
C33 D XM7_S 0.02395f
C34 XM21_D Q 0.40672f
C35 XM7_D XM10_D 0.26403f
C36 CLK XM26_D 0.05798f
C37 Q VDD 0.24171f
C38 XM26_D XM21_S 0.34885f
C39 XM7_S XM7_D 0.07721f
C40 XM26_D XM8_D 0.01049f
C41 XM26_D XM21_D 0.13818f
C42 Q GND 0.38206f
C43 CLK GND 1.00684f
C44 VDD GND 7.19156f
C45 XM21_S GND 0.56306f
C46 XM26_D GND 0.44246f
C47 XM8_D GND 0.33339f
C48 XM7_S GND 0.24271f
C49 XM21_D GND 1.81582f
C50 XM10_D GND 0.87765f
C51 RST GND 0.56693f
C52 XM7_D GND 0.92637f
C53 D GND 0.65003f
.ends
