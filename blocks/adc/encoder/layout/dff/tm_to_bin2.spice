* SPICE3 file created from tm_to_bin2.ext - technology: gf180mcuD

.option scale=5n

X0 VDD comp[3] NAND3_60/a_n593_982# VDD pfet_03v3 ad=85.8n pd=1.58m as=34.32n ps=0.764m w=660 l=56
X1 NAND3_60/a_n593_982# comp[3] VDD VDD pfet_03v3 ad=34.32n pd=0.764m as=34.32n ps=0.764m w=660 l=56
X2 NAND3_60/a_n593_982# comp[3] VDD VDD pfet_03v3 ad=34.32n pd=0.764m as=34.32n ps=0.764m w=660 l=56
X3 VDD comp[3] NAND3_60/a_n593_982# VDD pfet_03v3 ad=34.32n pd=0.764m as=85.8n ps=1.58m w=660 l=56
X4 VDD comp[3] NAND3_60/a_n593_982# VDD pfet_03v3 ad=34.32n pd=0.764m as=34.32n ps=0.764m w=660 l=56
X5 VDD comp[2] NAND3_60/a_2506_982# VDD pfet_03v3 ad=70.2702u pd=1.46034 as=0.66924u ps=0.01391 w=660 l=56
X6 NAND3_60/a_2506_982# comp[2] VDD VDD pfet_03v3 ad=0 pd=0 as=0 ps=0 w=660 l=56
X7 NAND3_60/a_2506_982# comp[2] VDD VDD pfet_03v3 ad=0 pd=0 as=0 ps=0 w=660 l=56
X8 VDD comp[2] NAND3_60/a_2506_982# VDD pfet_03v3 ad=0 pd=0 as=0 ps=0 w=660 l=56
X9 VDD comp[2] NAND3_60/a_2506_982# VDD pfet_03v3 ad=0 pd=0 as=0 ps=0 w=660 l=56
X10 VDD comp[1] NAND3_60/a_2506_982# VDD pfet_03v3 ad=0 pd=0 as=0 ps=0 w=660 l=56
X11 NAND3_60/a_2506_982# comp[1] VDD VDD pfet_03v3 ad=0 pd=0 as=0 ps=0 w=660 l=56
X12 NAND3_60/a_2506_982# comp[1] VDD VDD pfet_03v3 ad=0 pd=0 as=0 ps=0 w=660 l=56
X13 VDD comp[1] NAND3_60/a_2506_982# VDD pfet_03v3 ad=0 pd=0 as=0 ps=0 w=660 l=56
X14 VDD comp[1] NAND3_60/a_2506_982# VDD pfet_03v3 ad=0 pd=0 as=0 ps=0 w=660 l=56
X15 VDD NAND3_60/a_2506_982# wl[2] VDD pfet_03v3 ad=0 pd=0 as=0.22308u ps=4.636m w=660 l=56
X16 wl[2] NAND3_60/a_2506_982# VDD VDD pfet_03v3 ad=0 pd=0 as=0 ps=0 w=660 l=56
X17 wl[2] NAND3_60/a_2506_982# VDD VDD pfet_03v3 ad=0 pd=0 as=0 ps=0 w=660 l=56
X18 VDD NAND3_60/a_2506_982# wl[2] VDD pfet_03v3 ad=0 pd=0 as=0 ps=0 w=660 l=56
X19 VDD NAND3_60/a_2506_982# wl[2] VDD pfet_03v3 ad=0 pd=0 as=0 ps=0 w=660 l=56
X20 VDD NAND3_60/a_n593_982# NAND3_60/a_2506_982# VDD pfet_03v3 ad=0 pd=0 as=0 ps=0 w=660 l=56
X21 NAND3_60/a_2506_982# NAND3_60/a_n593_982# VDD VDD pfet_03v3 ad=0 pd=0 as=0 ps=0 w=660 l=56
X22 NAND3_60/a_2506_982# NAND3_60/a_n593_982# VDD VDD pfet_03v3 ad=0 pd=0 as=0 ps=0 w=660 l=56
X23 VDD NAND3_60/a_n593_982# NAND3_60/a_2506_982# VDD pfet_03v3 ad=0 pd=0 as=0 ps=0 w=660 l=56
X24 VDD NAND3_60/a_n593_982# NAND3_60/a_2506_982# VDD pfet_03v3 ad=0 pd=0 as=0 ps=0 w=660 l=56
X25 NAND3_60/m1_n2243_n1314# comp[2] NAND3_60/m1_n3706_n1374# GND nfet_03v3 ad=26.416n pd=0.612m as=26.416n ps=0.612m w=508 l=56
X26 NAND3_60/m1_n2243_n1314# comp[2] NAND3_60/m1_n3706_n1374# GND nfet_03v3 ad=61.976n pd=1.26m as=26.416n ps=0.612m w=508 l=56
X27 NAND3_60/m1_n3706_n1374# comp[2] NAND3_60/m1_n2243_n1314# GND nfet_03v3 ad=26.416n pd=0.612m as=61.976n ps=1.26m w=508 l=56
X28 NAND3_60/m1_n3706_n1374# comp[2] NAND3_60/m1_n2243_n1314# GND nfet_03v3 ad=26.416n pd=0.612m as=26.416n ps=0.612m w=508 l=56
X29 GND comp[3] NAND3_60/a_n593_982# GND nfet_03v3 ad=33.41217u pd=0.70762 as=0.10566u ps=2.448m w=508 l=56
X30 GND comp[3] NAND3_60/a_n593_982# GND nfet_03v3 ad=0 pd=0 as=0 ps=0 w=508 l=56
X31 NAND3_60/a_n593_982# comp[3] GND GND nfet_03v3 ad=0 pd=0 as=0 ps=0 w=508 l=56
X32 NAND3_60/a_n593_982# comp[3] GND GND nfet_03v3 ad=0 pd=0 as=0 ps=0 w=508 l=56
X33 GND NAND3_60/a_n593_982# NAND3_60/m1_n2243_n1314# GND nfet_03v3 ad=0 pd=0 as=0.28245u ps=6.192m w=508 l=56
X34 GND NAND3_60/a_n593_982# NAND3_60/m1_n2243_n1314# GND nfet_03v3 ad=0 pd=0 as=0 ps=0 w=508 l=56
X35 NAND3_60/m1_n2243_n1314# NAND3_60/a_n593_982# GND GND nfet_03v3 ad=0 pd=0 as=0 ps=0 w=508 l=56
X36 NAND3_60/m1_n2243_n1314# NAND3_60/a_n593_982# GND GND nfet_03v3 ad=0 pd=0 as=0 ps=0 w=508 l=56
X37 NAND3_60/m1_n3706_n1374# comp[1] NAND3_60/a_2506_982# GND nfet_03v3 ad=0.28245u pd=6.192m as=0.10566u ps=2.448m w=508 l=56
X38 NAND3_60/m1_n3706_n1374# comp[1] NAND3_60/a_2506_982# GND nfet_03v3 ad=0 pd=0 as=0 ps=0 w=508 l=56
X39 NAND3_60/a_2506_982# comp[1] NAND3_60/m1_n3706_n1374# GND nfet_03v3 ad=0 pd=0 as=0 ps=0 w=508 l=56
X40 NAND3_60/a_2506_982# comp[1] NAND3_60/m1_n3706_n1374# GND nfet_03v3 ad=0 pd=0 as=0 ps=0 w=508 l=56
X41 GND NAND3_60/a_2506_982# wl[2] GND nfet_03v3 ad=0 pd=0 as=0.10566u ps=2.448m w=508 l=56
X42 GND NAND3_60/a_2506_982# wl[2] GND nfet_03v3 ad=0 pd=0 as=0 ps=0 w=508 l=56
X43 wl[2] NAND3_60/a_2506_982# GND GND nfet_03v3 ad=0 pd=0 as=0 ps=0 w=508 l=56
X44 wl[2] NAND3_60/a_2506_982# GND GND nfet_03v3 ad=0 pd=0 as=0 ps=0 w=508 l=56
X45 VDD comp[13] NAND3_50/a_n593_982# VDD pfet_03v3 ad=0 pd=0 as=0.22308u ps=4.636m w=660 l=56
X46 NAND3_50/a_n593_982# comp[13] VDD VDD pfet_03v3 ad=0 pd=0 as=0 ps=0 w=660 l=56
X47 NAND3_50/a_n593_982# comp[13] VDD VDD pfet_03v3 ad=0 pd=0 as=0 ps=0 w=660 l=56
X48 VDD comp[13] NAND3_50/a_n593_982# VDD pfet_03v3 ad=0 pd=0 as=0 ps=0 w=660 l=56
X49 VDD comp[13] NAND3_50/a_n593_982# VDD pfet_03v3 ad=0 pd=0 as=0 ps=0 w=660 l=56
X50 VDD comp[12] NAND3_50/a_2506_982# VDD pfet_03v3 ad=0 pd=0 as=0.66924u ps=0.01391 w=660 l=56
X51 NAND3_50/a_2506_982# comp[12] VDD VDD pfet_03v3 ad=0 pd=0 as=0 ps=0 w=660 l=56
X52 NAND3_50/a_2506_982# comp[12] VDD VDD pfet_03v3 ad=0 pd=0 as=0 ps=0 w=660 l=56
X53 VDD comp[12] NAND3_50/a_2506_982# VDD pfet_03v3 ad=0 pd=0 as=0 ps=0 w=660 l=56
X54 VDD comp[12] NAND3_50/a_2506_982# VDD pfet_03v3 ad=0 pd=0 as=0 ps=0 w=660 l=56
X55 VDD comp[11] NAND3_50/a_2506_982# VDD pfet_03v3 ad=0 pd=0 as=0 ps=0 w=660 l=56
X56 NAND3_50/a_2506_982# comp[11] VDD VDD pfet_03v3 ad=0 pd=0 as=0 ps=0 w=660 l=56
X57 NAND3_50/a_2506_982# comp[11] VDD VDD pfet_03v3 ad=0 pd=0 as=0 ps=0 w=660 l=56
X58 VDD comp[11] NAND3_50/a_2506_982# VDD pfet_03v3 ad=0 pd=0 as=0 ps=0 w=660 l=56
X59 VDD comp[11] NAND3_50/a_2506_982# VDD pfet_03v3 ad=0 pd=0 as=0 ps=0 w=660 l=56
X60 VDD NAND3_50/a_2506_982# wl[12] VDD pfet_03v3 ad=0 pd=0 as=0.22308u ps=4.636m w=660 l=56
X61 wl[12] NAND3_50/a_2506_982# VDD VDD pfet_03v3 ad=0 pd=0 as=0 ps=0 w=660 l=56
X62 wl[12] NAND3_50/a_2506_982# VDD VDD pfet_03v3 ad=0 pd=0 as=0 ps=0 w=660 l=56
X63 VDD NAND3_50/a_2506_982# wl[12] VDD pfet_03v3 ad=0 pd=0 as=0 ps=0 w=660 l=56
X64 VDD NAND3_50/a_2506_982# wl[12] VDD pfet_03v3 ad=0 pd=0 as=0 ps=0 w=660 l=56
X65 VDD NAND3_50/a_n593_982# NAND3_50/a_2506_982# VDD pfet_03v3 ad=0 pd=0 as=0 ps=0 w=660 l=56
X66 NAND3_50/a_2506_982# NAND3_50/a_n593_982# VDD VDD pfet_03v3 ad=0 pd=0 as=0 ps=0 w=660 l=56
X67 NAND3_50/a_2506_982# NAND3_50/a_n593_982# VDD VDD pfet_03v3 ad=0 pd=0 as=0 ps=0 w=660 l=56
X68 VDD NAND3_50/a_n593_982# NAND3_50/a_2506_982# VDD pfet_03v3 ad=0 pd=0 as=0 ps=0 w=660 l=56
X69 VDD NAND3_50/a_n593_982# NAND3_50/a_2506_982# VDD pfet_03v3 ad=0 pd=0 as=0 ps=0 w=660 l=56
X70 NAND3_50/m1_n2243_n1314# comp[12] NAND3_50/m1_n3706_n1374# GND nfet_03v3 ad=0.28245u pd=6.192m as=0.28245u ps=6.192m w=508 l=56
X71 NAND3_50/m1_n2243_n1314# comp[12] NAND3_50/m1_n3706_n1374# GND nfet_03v3 ad=0 pd=0 as=0 ps=0 w=508 l=56
X72 NAND3_50/m1_n3706_n1374# comp[12] NAND3_50/m1_n2243_n1314# GND nfet_03v3 ad=0 pd=0 as=0 ps=0 w=508 l=56
X73 NAND3_50/m1_n3706_n1374# comp[12] NAND3_50/m1_n2243_n1314# GND nfet_03v3 ad=0 pd=0 as=0 ps=0 w=508 l=56
X74 GND comp[13] NAND3_50/a_n593_982# GND nfet_03v3 ad=0 pd=0 as=0.10566u ps=2.448m w=508 l=56
X75 GND comp[13] NAND3_50/a_n593_982# GND nfet_03v3 ad=0 pd=0 as=0 ps=0 w=508 l=56
X76 NAND3_50/a_n593_982# comp[13] GND GND nfet_03v3 ad=0 pd=0 as=0 ps=0 w=508 l=56
X77 NAND3_50/a_n593_982# comp[13] GND GND nfet_03v3 ad=0 pd=0 as=0 ps=0 w=508 l=56
X78 GND NAND3_50/a_n593_982# NAND3_50/m1_n2243_n1314# GND nfet_03v3 ad=0 pd=0 as=0 ps=0 w=508 l=56
X79 GND NAND3_50/a_n593_982# NAND3_50/m1_n2243_n1314# GND nfet_03v3 ad=0 pd=0 as=0 ps=0 w=508 l=56
X80 NAND3_50/m1_n2243_n1314# NAND3_50/a_n593_982# GND GND nfet_03v3 ad=0 pd=0 as=0 ps=0 w=508 l=56
X81 NAND3_50/m1_n2243_n1314# NAND3_50/a_n593_982# GND GND nfet_03v3 ad=0 pd=0 as=0 ps=0 w=508 l=56
X82 NAND3_50/m1_n3706_n1374# comp[11] NAND3_50/a_2506_982# GND nfet_03v3 ad=0 pd=0 as=0.10566u ps=2.448m w=508 l=56
X83 NAND3_50/m1_n3706_n1374# comp[11] NAND3_50/a_2506_982# GND nfet_03v3 ad=0 pd=0 as=0 ps=0 w=508 l=56
X84 NAND3_50/a_2506_982# comp[11] NAND3_50/m1_n3706_n1374# GND nfet_03v3 ad=0 pd=0 as=0 ps=0 w=508 l=56
X85 NAND3_50/a_2506_982# comp[11] NAND3_50/m1_n3706_n1374# GND nfet_03v3 ad=0 pd=0 as=0 ps=0 w=508 l=56
X86 GND NAND3_50/a_2506_982# wl[12] GND nfet_03v3 ad=0 pd=0 as=0.10566u ps=2.448m w=508 l=56
X87 GND NAND3_50/a_2506_982# wl[12] GND nfet_03v3 ad=0 pd=0 as=0 ps=0 w=508 l=56
X88 wl[12] NAND3_50/a_2506_982# GND GND nfet_03v3 ad=0 pd=0 as=0 ps=0 w=508 l=56
X89 wl[12] NAND3_50/a_2506_982# GND GND nfet_03v3 ad=0 pd=0 as=0 ps=0 w=508 l=56
X90 VDD comp[2] NAND3_61/a_n593_982# VDD pfet_03v3 ad=0 pd=0 as=0.22308u ps=4.636m w=660 l=56
X91 NAND3_61/a_n593_982# comp[2] VDD VDD pfet_03v3 ad=0 pd=0 as=0 ps=0 w=660 l=56
X92 NAND3_61/a_n593_982# comp[2] VDD VDD pfet_03v3 ad=0 pd=0 as=0 ps=0 w=660 l=56
X93 VDD comp[2] NAND3_61/a_n593_982# VDD pfet_03v3 ad=0 pd=0 as=0 ps=0 w=660 l=56
X94 VDD comp[2] NAND3_61/a_n593_982# VDD pfet_03v3 ad=0 pd=0 as=0 ps=0 w=660 l=56
X95 VDD comp[1] NAND3_61/a_2506_982# VDD pfet_03v3 ad=0 pd=0 as=0.66924u ps=0.01391 w=660 l=56
X96 NAND3_61/a_2506_982# comp[1] VDD VDD pfet_03v3 ad=0 pd=0 as=0 ps=0 w=660 l=56
X97 NAND3_61/a_2506_982# comp[1] VDD VDD pfet_03v3 ad=0 pd=0 as=0 ps=0 w=660 l=56
X98 VDD comp[1] NAND3_61/a_2506_982# VDD pfet_03v3 ad=0 pd=0 as=0 ps=0 w=660 l=56
X99 VDD comp[1] NAND3_61/a_2506_982# VDD pfet_03v3 ad=0 pd=0 as=0 ps=0 w=660 l=56
X100 VDD m1_n4168_2156# NAND3_61/a_2506_982# VDD pfet_03v3 ad=0 pd=0 as=0 ps=0 w=660 l=56
X101 NAND3_61/a_2506_982# m1_n4168_2156# VDD VDD pfet_03v3 ad=0 pd=0 as=0 ps=0 w=660 l=56
X102 NAND3_61/a_2506_982# m1_n4168_2156# VDD VDD pfet_03v3 ad=0 pd=0 as=0 ps=0 w=660 l=56
X103 VDD m1_n4168_2156# NAND3_61/a_2506_982# VDD pfet_03v3 ad=0 pd=0 as=0 ps=0 w=660 l=56
X104 VDD m1_n4168_2156# NAND3_61/a_2506_982# VDD pfet_03v3 ad=0 pd=0 as=0 ps=0 w=660 l=56
X105 VDD NAND3_61/a_2506_982# wl[1] VDD pfet_03v3 ad=0 pd=0 as=0.22308u ps=4.636m w=660 l=56
X106 wl[1] NAND3_61/a_2506_982# VDD VDD pfet_03v3 ad=0 pd=0 as=0 ps=0 w=660 l=56
X107 wl[1] NAND3_61/a_2506_982# VDD VDD pfet_03v3 ad=0 pd=0 as=0 ps=0 w=660 l=56
X108 VDD NAND3_61/a_2506_982# wl[1] VDD pfet_03v3 ad=0 pd=0 as=0 ps=0 w=660 l=56
X109 VDD NAND3_61/a_2506_982# wl[1] VDD pfet_03v3 ad=0 pd=0 as=0 ps=0 w=660 l=56
X110 VDD NAND3_61/a_n593_982# NAND3_61/a_2506_982# VDD pfet_03v3 ad=0 pd=0 as=0 ps=0 w=660 l=56
X111 NAND3_61/a_2506_982# NAND3_61/a_n593_982# VDD VDD pfet_03v3 ad=0 pd=0 as=0 ps=0 w=660 l=56
X112 NAND3_61/a_2506_982# NAND3_61/a_n593_982# VDD VDD pfet_03v3 ad=0 pd=0 as=0 ps=0 w=660 l=56
X113 VDD NAND3_61/a_n593_982# NAND3_61/a_2506_982# VDD pfet_03v3 ad=0 pd=0 as=0 ps=0 w=660 l=56
X114 VDD NAND3_61/a_n593_982# NAND3_61/a_2506_982# VDD pfet_03v3 ad=0 pd=0 as=0 ps=0 w=660 l=56
X115 NAND3_61/m1_n2243_n1314# comp[1] NAND3_61/m1_n3706_n1374# GND nfet_03v3 ad=0.28245u pd=6.192m as=0.28245u ps=6.192m w=508 l=56
X116 NAND3_61/m1_n2243_n1314# comp[1] NAND3_61/m1_n3706_n1374# GND nfet_03v3 ad=0 pd=0 as=0 ps=0 w=508 l=56
X117 NAND3_61/m1_n3706_n1374# comp[1] NAND3_61/m1_n2243_n1314# GND nfet_03v3 ad=0 pd=0 as=0 ps=0 w=508 l=56
X118 NAND3_61/m1_n3706_n1374# comp[1] NAND3_61/m1_n2243_n1314# GND nfet_03v3 ad=0 pd=0 as=0 ps=0 w=508 l=56
X119 GND comp[2] NAND3_61/a_n593_982# GND nfet_03v3 ad=0 pd=0 as=0.10566u ps=2.448m w=508 l=56
X120 GND comp[2] NAND3_61/a_n593_982# GND nfet_03v3 ad=0 pd=0 as=0 ps=0 w=508 l=56
X121 NAND3_61/a_n593_982# comp[2] GND GND nfet_03v3 ad=0 pd=0 as=0 ps=0 w=508 l=56
X122 NAND3_61/a_n593_982# comp[2] GND GND nfet_03v3 ad=0 pd=0 as=0 ps=0 w=508 l=56
X123 GND NAND3_61/a_n593_982# NAND3_61/m1_n2243_n1314# GND nfet_03v3 ad=0 pd=0 as=0 ps=0 w=508 l=56
X124 GND NAND3_61/a_n593_982# NAND3_61/m1_n2243_n1314# GND nfet_03v3 ad=0 pd=0 as=0 ps=0 w=508 l=56
X125 NAND3_61/m1_n2243_n1314# NAND3_61/a_n593_982# GND GND nfet_03v3 ad=0 pd=0 as=0 ps=0 w=508 l=56
X126 NAND3_61/m1_n2243_n1314# NAND3_61/a_n593_982# GND GND nfet_03v3 ad=0 pd=0 as=0 ps=0 w=508 l=56
X127 NAND3_61/m1_n3706_n1374# m1_n4168_2156# NAND3_61/a_2506_982# GND nfet_03v3 ad=0 pd=0 as=0.10566u ps=2.448m w=508 l=56
X128 NAND3_61/m1_n3706_n1374# m1_n4168_2156# NAND3_61/a_2506_982# GND nfet_03v3 ad=0 pd=0 as=0 ps=0 w=508 l=56
X129 NAND3_61/a_2506_982# m1_n4168_2156# NAND3_61/m1_n3706_n1374# GND nfet_03v3 ad=0 pd=0 as=0 ps=0 w=508 l=56
X130 NAND3_61/a_2506_982# m1_n4168_2156# NAND3_61/m1_n3706_n1374# GND nfet_03v3 ad=0 pd=0 as=0 ps=0 w=508 l=56
X131 GND NAND3_61/a_2506_982# wl[1] GND nfet_03v3 ad=0 pd=0 as=0.10566u ps=2.448m w=508 l=56
X132 GND NAND3_61/a_2506_982# wl[1] GND nfet_03v3 ad=0 pd=0 as=0 ps=0 w=508 l=56
X133 wl[1] NAND3_61/a_2506_982# GND GND nfet_03v3 ad=0 pd=0 as=0 ps=0 w=508 l=56
X134 wl[1] NAND3_61/a_2506_982# GND GND nfet_03v3 ad=0 pd=0 as=0 ps=0 w=508 l=56
X135 VDD comp[23] NAND3_40/a_n593_982# VDD pfet_03v3 ad=0 pd=0 as=0.22308u ps=4.636m w=660 l=56
X136 NAND3_40/a_n593_982# comp[23] VDD VDD pfet_03v3 ad=0 pd=0 as=0 ps=0 w=660 l=56
X137 NAND3_40/a_n593_982# comp[23] VDD VDD pfet_03v3 ad=0 pd=0 as=0 ps=0 w=660 l=56
X138 VDD comp[23] NAND3_40/a_n593_982# VDD pfet_03v3 ad=0 pd=0 as=0 ps=0 w=660 l=56
X139 VDD comp[23] NAND3_40/a_n593_982# VDD pfet_03v3 ad=0 pd=0 as=0 ps=0 w=660 l=56
X140 VDD comp[22] NAND3_40/a_2506_982# VDD pfet_03v3 ad=0 pd=0 as=0.66924u ps=0.01391 w=660 l=56
X141 NAND3_40/a_2506_982# comp[22] VDD VDD pfet_03v3 ad=0 pd=0 as=0 ps=0 w=660 l=56
X142 NAND3_40/a_2506_982# comp[22] VDD VDD pfet_03v3 ad=0 pd=0 as=0 ps=0 w=660 l=56
X143 VDD comp[22] NAND3_40/a_2506_982# VDD pfet_03v3 ad=0 pd=0 as=0 ps=0 w=660 l=56
X144 VDD comp[22] NAND3_40/a_2506_982# VDD pfet_03v3 ad=0 pd=0 as=0 ps=0 w=660 l=56
X145 VDD comp[21] NAND3_40/a_2506_982# VDD pfet_03v3 ad=0 pd=0 as=0 ps=0 w=660 l=56
X146 NAND3_40/a_2506_982# comp[21] VDD VDD pfet_03v3 ad=0 pd=0 as=0 ps=0 w=660 l=56
X147 NAND3_40/a_2506_982# comp[21] VDD VDD pfet_03v3 ad=0 pd=0 as=0 ps=0 w=660 l=56
X148 VDD comp[21] NAND3_40/a_2506_982# VDD pfet_03v3 ad=0 pd=0 as=0 ps=0 w=660 l=56
X149 VDD comp[21] NAND3_40/a_2506_982# VDD pfet_03v3 ad=0 pd=0 as=0 ps=0 w=660 l=56
X150 VDD NAND3_40/a_2506_982# wl[22] VDD pfet_03v3 ad=0 pd=0 as=0.22308u ps=4.636m w=660 l=56
X151 wl[22] NAND3_40/a_2506_982# VDD VDD pfet_03v3 ad=0 pd=0 as=0 ps=0 w=660 l=56
X152 wl[22] NAND3_40/a_2506_982# VDD VDD pfet_03v3 ad=0 pd=0 as=0 ps=0 w=660 l=56
X153 VDD NAND3_40/a_2506_982# wl[22] VDD pfet_03v3 ad=0 pd=0 as=0 ps=0 w=660 l=56
X154 VDD NAND3_40/a_2506_982# wl[22] VDD pfet_03v3 ad=0 pd=0 as=0 ps=0 w=660 l=56
X155 VDD NAND3_40/a_n593_982# NAND3_40/a_2506_982# VDD pfet_03v3 ad=0 pd=0 as=0 ps=0 w=660 l=56
X156 NAND3_40/a_2506_982# NAND3_40/a_n593_982# VDD VDD pfet_03v3 ad=0 pd=0 as=0 ps=0 w=660 l=56
X157 NAND3_40/a_2506_982# NAND3_40/a_n593_982# VDD VDD pfet_03v3 ad=0 pd=0 as=0 ps=0 w=660 l=56
X158 VDD NAND3_40/a_n593_982# NAND3_40/a_2506_982# VDD pfet_03v3 ad=0 pd=0 as=0 ps=0 w=660 l=56
X159 VDD NAND3_40/a_n593_982# NAND3_40/a_2506_982# VDD pfet_03v3 ad=0 pd=0 as=0 ps=0 w=660 l=56
X160 NAND3_40/m1_n2243_n1314# comp[22] NAND3_40/m1_n3706_n1374# GND nfet_03v3 ad=0.28245u pd=6.192m as=0.28245u ps=6.192m w=508 l=56
X161 NAND3_40/m1_n2243_n1314# comp[22] NAND3_40/m1_n3706_n1374# GND nfet_03v3 ad=0 pd=0 as=0 ps=0 w=508 l=56
X162 NAND3_40/m1_n3706_n1374# comp[22] NAND3_40/m1_n2243_n1314# GND nfet_03v3 ad=0 pd=0 as=0 ps=0 w=508 l=56
X163 NAND3_40/m1_n3706_n1374# comp[22] NAND3_40/m1_n2243_n1314# GND nfet_03v3 ad=0 pd=0 as=0 ps=0 w=508 l=56
X164 GND comp[23] NAND3_40/a_n593_982# GND nfet_03v3 ad=0 pd=0 as=0.10566u ps=2.448m w=508 l=56
X165 GND comp[23] NAND3_40/a_n593_982# GND nfet_03v3 ad=0 pd=0 as=0 ps=0 w=508 l=56
X166 NAND3_40/a_n593_982# comp[23] GND GND nfet_03v3 ad=0 pd=0 as=0 ps=0 w=508 l=56
X167 NAND3_40/a_n593_982# comp[23] GND GND nfet_03v3 ad=0 pd=0 as=0 ps=0 w=508 l=56
X168 GND NAND3_40/a_n593_982# NAND3_40/m1_n2243_n1314# GND nfet_03v3 ad=0 pd=0 as=0 ps=0 w=508 l=56
X169 GND NAND3_40/a_n593_982# NAND3_40/m1_n2243_n1314# GND nfet_03v3 ad=0 pd=0 as=0 ps=0 w=508 l=56
X170 NAND3_40/m1_n2243_n1314# NAND3_40/a_n593_982# GND GND nfet_03v3 ad=0 pd=0 as=0 ps=0 w=508 l=56
X171 NAND3_40/m1_n2243_n1314# NAND3_40/a_n593_982# GND GND nfet_03v3 ad=0 pd=0 as=0 ps=0 w=508 l=56
X172 NAND3_40/m1_n3706_n1374# comp[21] NAND3_40/a_2506_982# GND nfet_03v3 ad=0 pd=0 as=0.10566u ps=2.448m w=508 l=56
X173 NAND3_40/m1_n3706_n1374# comp[21] NAND3_40/a_2506_982# GND nfet_03v3 ad=0 pd=0 as=0 ps=0 w=508 l=56
X174 NAND3_40/a_2506_982# comp[21] NAND3_40/m1_n3706_n1374# GND nfet_03v3 ad=0 pd=0 as=0 ps=0 w=508 l=56
X175 NAND3_40/a_2506_982# comp[21] NAND3_40/m1_n3706_n1374# GND nfet_03v3 ad=0 pd=0 as=0 ps=0 w=508 l=56
X176 GND NAND3_40/a_2506_982# wl[22] GND nfet_03v3 ad=0 pd=0 as=0.10566u ps=2.448m w=508 l=56
X177 GND NAND3_40/a_2506_982# wl[22] GND nfet_03v3 ad=0 pd=0 as=0 ps=0 w=508 l=56
X178 wl[22] NAND3_40/a_2506_982# GND GND nfet_03v3 ad=0 pd=0 as=0 ps=0 w=508 l=56
X179 wl[22] NAND3_40/a_2506_982# GND GND nfet_03v3 ad=0 pd=0 as=0 ps=0 w=508 l=56
X180 VDD comp[12] NAND3_51/a_n593_982# VDD pfet_03v3 ad=0 pd=0 as=0.22308u ps=4.636m w=660 l=56
X181 NAND3_51/a_n593_982# comp[12] VDD VDD pfet_03v3 ad=0 pd=0 as=0 ps=0 w=660 l=56
X182 NAND3_51/a_n593_982# comp[12] VDD VDD pfet_03v3 ad=0 pd=0 as=0 ps=0 w=660 l=56
X183 VDD comp[12] NAND3_51/a_n593_982# VDD pfet_03v3 ad=0 pd=0 as=0 ps=0 w=660 l=56
X184 VDD comp[12] NAND3_51/a_n593_982# VDD pfet_03v3 ad=0 pd=0 as=0 ps=0 w=660 l=56
X185 VDD comp[11] NAND3_51/a_2506_982# VDD pfet_03v3 ad=0 pd=0 as=0.66924u ps=0.01391 w=660 l=56
X186 NAND3_51/a_2506_982# comp[11] VDD VDD pfet_03v3 ad=0 pd=0 as=0 ps=0 w=660 l=56
X187 NAND3_51/a_2506_982# comp[11] VDD VDD pfet_03v3 ad=0 pd=0 as=0 ps=0 w=660 l=56
X188 VDD comp[11] NAND3_51/a_2506_982# VDD pfet_03v3 ad=0 pd=0 as=0 ps=0 w=660 l=56
X189 VDD comp[11] NAND3_51/a_2506_982# VDD pfet_03v3 ad=0 pd=0 as=0 ps=0 w=660 l=56
X190 VDD comp[10] NAND3_51/a_2506_982# VDD pfet_03v3 ad=0 pd=0 as=0 ps=0 w=660 l=56
X191 NAND3_51/a_2506_982# comp[10] VDD VDD pfet_03v3 ad=0 pd=0 as=0 ps=0 w=660 l=56
X192 NAND3_51/a_2506_982# comp[10] VDD VDD pfet_03v3 ad=0 pd=0 as=0 ps=0 w=660 l=56
X193 VDD comp[10] NAND3_51/a_2506_982# VDD pfet_03v3 ad=0 pd=0 as=0 ps=0 w=660 l=56
X194 VDD comp[10] NAND3_51/a_2506_982# VDD pfet_03v3 ad=0 pd=0 as=0 ps=0 w=660 l=56
X195 VDD NAND3_51/a_2506_982# wl[11] VDD pfet_03v3 ad=0 pd=0 as=0.22308u ps=4.636m w=660 l=56
X196 wl[11] NAND3_51/a_2506_982# VDD VDD pfet_03v3 ad=0 pd=0 as=0 ps=0 w=660 l=56
X197 wl[11] NAND3_51/a_2506_982# VDD VDD pfet_03v3 ad=0 pd=0 as=0 ps=0 w=660 l=56
X198 VDD NAND3_51/a_2506_982# wl[11] VDD pfet_03v3 ad=0 pd=0 as=0 ps=0 w=660 l=56
X199 VDD NAND3_51/a_2506_982# wl[11] VDD pfet_03v3 ad=0 pd=0 as=0 ps=0 w=660 l=56
X200 VDD NAND3_51/a_n593_982# NAND3_51/a_2506_982# VDD pfet_03v3 ad=0 pd=0 as=0 ps=0 w=660 l=56
X201 NAND3_51/a_2506_982# NAND3_51/a_n593_982# VDD VDD pfet_03v3 ad=0 pd=0 as=0 ps=0 w=660 l=56
X202 NAND3_51/a_2506_982# NAND3_51/a_n593_982# VDD VDD pfet_03v3 ad=0 pd=0 as=0 ps=0 w=660 l=56
X203 VDD NAND3_51/a_n593_982# NAND3_51/a_2506_982# VDD pfet_03v3 ad=0 pd=0 as=0 ps=0 w=660 l=56
X204 VDD NAND3_51/a_n593_982# NAND3_51/a_2506_982# VDD pfet_03v3 ad=0 pd=0 as=0 ps=0 w=660 l=56
X205 NAND3_51/m1_n2243_n1314# comp[11] NAND3_51/m1_n3706_n1374# GND nfet_03v3 ad=0.28245u pd=6.192m as=0.28245u ps=6.192m w=508 l=56
X206 NAND3_51/m1_n2243_n1314# comp[11] NAND3_51/m1_n3706_n1374# GND nfet_03v3 ad=0 pd=0 as=0 ps=0 w=508 l=56
X207 NAND3_51/m1_n3706_n1374# comp[11] NAND3_51/m1_n2243_n1314# GND nfet_03v3 ad=0 pd=0 as=0 ps=0 w=508 l=56
X208 NAND3_51/m1_n3706_n1374# comp[11] NAND3_51/m1_n2243_n1314# GND nfet_03v3 ad=0 pd=0 as=0 ps=0 w=508 l=56
X209 GND comp[12] NAND3_51/a_n593_982# GND nfet_03v3 ad=0 pd=0 as=0.10566u ps=2.448m w=508 l=56
X210 GND comp[12] NAND3_51/a_n593_982# GND nfet_03v3 ad=0 pd=0 as=0 ps=0 w=508 l=56
X211 NAND3_51/a_n593_982# comp[12] GND GND nfet_03v3 ad=0 pd=0 as=0 ps=0 w=508 l=56
X212 NAND3_51/a_n593_982# comp[12] GND GND nfet_03v3 ad=0 pd=0 as=0 ps=0 w=508 l=56
X213 GND NAND3_51/a_n593_982# NAND3_51/m1_n2243_n1314# GND nfet_03v3 ad=0 pd=0 as=0 ps=0 w=508 l=56
X214 GND NAND3_51/a_n593_982# NAND3_51/m1_n2243_n1314# GND nfet_03v3 ad=0 pd=0 as=0 ps=0 w=508 l=56
X215 NAND3_51/m1_n2243_n1314# NAND3_51/a_n593_982# GND GND nfet_03v3 ad=0 pd=0 as=0 ps=0 w=508 l=56
X216 NAND3_51/m1_n2243_n1314# NAND3_51/a_n593_982# GND GND nfet_03v3 ad=0 pd=0 as=0 ps=0 w=508 l=56
X217 NAND3_51/m1_n3706_n1374# comp[10] NAND3_51/a_2506_982# GND nfet_03v3 ad=0 pd=0 as=0.10566u ps=2.448m w=508 l=56
X218 NAND3_51/m1_n3706_n1374# comp[10] NAND3_51/a_2506_982# GND nfet_03v3 ad=0 pd=0 as=0 ps=0 w=508 l=56
X219 NAND3_51/a_2506_982# comp[10] NAND3_51/m1_n3706_n1374# GND nfet_03v3 ad=0 pd=0 as=0 ps=0 w=508 l=56
X220 NAND3_51/a_2506_982# comp[10] NAND3_51/m1_n3706_n1374# GND nfet_03v3 ad=0 pd=0 as=0 ps=0 w=508 l=56
X221 GND NAND3_51/a_2506_982# wl[11] GND nfet_03v3 ad=0 pd=0 as=0.10566u ps=2.448m w=508 l=56
X222 GND NAND3_51/a_2506_982# wl[11] GND nfet_03v3 ad=0 pd=0 as=0 ps=0 w=508 l=56
X223 wl[11] NAND3_51/a_2506_982# GND GND nfet_03v3 ad=0 pd=0 as=0 ps=0 w=508 l=56
X224 wl[11] NAND3_51/a_2506_982# GND GND nfet_03v3 ad=0 pd=0 as=0 ps=0 w=508 l=56
X225 VDD comp[1] NAND3_62/a_n593_982# VDD pfet_03v3 ad=0 pd=0 as=0.22308u ps=4.636m w=660 l=56
X226 NAND3_62/a_n593_982# comp[1] VDD VDD pfet_03v3 ad=0 pd=0 as=0 ps=0 w=660 l=56
X227 NAND3_62/a_n593_982# comp[1] VDD VDD pfet_03v3 ad=0 pd=0 as=0 ps=0 w=660 l=56
X228 VDD comp[1] NAND3_62/a_n593_982# VDD pfet_03v3 ad=0 pd=0 as=0 ps=0 w=660 l=56
X229 VDD comp[1] NAND3_62/a_n593_982# VDD pfet_03v3 ad=0 pd=0 as=0 ps=0 w=660 l=56
X230 VDD m1_n4168_2156# NAND3_62/a_2506_982# VDD pfet_03v3 ad=0 pd=0 as=0.66924u ps=0.01391 w=660 l=56
X231 NAND3_62/a_2506_982# m1_n4168_2156# VDD VDD pfet_03v3 ad=0 pd=0 as=0 ps=0 w=660 l=56
X232 NAND3_62/a_2506_982# m1_n4168_2156# VDD VDD pfet_03v3 ad=0 pd=0 as=0 ps=0 w=660 l=56
X233 VDD m1_n4168_2156# NAND3_62/a_2506_982# VDD pfet_03v3 ad=0 pd=0 as=0 ps=0 w=660 l=56
X234 VDD m1_n4168_2156# NAND3_62/a_2506_982# VDD pfet_03v3 ad=0 pd=0 as=0 ps=0 w=660 l=56
X235 VDD VDD NAND3_62/a_2506_982# VDD pfet_03v3 ad=0 pd=0 as=0 ps=0 w=660 l=56
X236 NAND3_62/a_2506_982# VDD VDD VDD pfet_03v3 ad=0 pd=0 as=0 ps=0 w=660 l=56
X237 NAND3_62/a_2506_982# VDD VDD VDD pfet_03v3 ad=0 pd=0 as=0 ps=0 w=660 l=56
X238 VDD VDD NAND3_62/a_2506_982# VDD pfet_03v3 ad=0 pd=0 as=0 ps=0 w=660 l=56
X239 VDD VDD NAND3_62/a_2506_982# VDD pfet_03v3 ad=0 pd=0 as=0 ps=0 w=660 l=56
X240 VDD NAND3_62/a_2506_982# wl[0] VDD pfet_03v3 ad=0 pd=0 as=0.22308u ps=4.636m w=660 l=56
X241 wl[0] NAND3_62/a_2506_982# VDD VDD pfet_03v3 ad=0 pd=0 as=0 ps=0 w=660 l=56
X242 wl[0] NAND3_62/a_2506_982# VDD VDD pfet_03v3 ad=0 pd=0 as=0 ps=0 w=660 l=56
X243 VDD NAND3_62/a_2506_982# wl[0] VDD pfet_03v3 ad=0 pd=0 as=0 ps=0 w=660 l=56
X244 VDD NAND3_62/a_2506_982# wl[0] VDD pfet_03v3 ad=0 pd=0 as=0 ps=0 w=660 l=56
X245 VDD NAND3_62/a_n593_982# NAND3_62/a_2506_982# VDD pfet_03v3 ad=0 pd=0 as=0 ps=0 w=660 l=56
X246 NAND3_62/a_2506_982# NAND3_62/a_n593_982# VDD VDD pfet_03v3 ad=0 pd=0 as=0 ps=0 w=660 l=56
X247 NAND3_62/a_2506_982# NAND3_62/a_n593_982# VDD VDD pfet_03v3 ad=0 pd=0 as=0 ps=0 w=660 l=56
X248 VDD NAND3_62/a_n593_982# NAND3_62/a_2506_982# VDD pfet_03v3 ad=0 pd=0 as=0 ps=0 w=660 l=56
X249 VDD NAND3_62/a_n593_982# NAND3_62/a_2506_982# VDD pfet_03v3 ad=0 pd=0 as=0 ps=0 w=660 l=56
X250 NAND3_62/m1_n2243_n1314# m1_n4168_2156# NAND3_62/m1_n3706_n1374# GND nfet_03v3 ad=0.28245u pd=6.192m as=0.28245u ps=6.192m w=508 l=56
X251 NAND3_62/m1_n2243_n1314# m1_n4168_2156# NAND3_62/m1_n3706_n1374# GND nfet_03v3 ad=0 pd=0 as=0 ps=0 w=508 l=56
X252 NAND3_62/m1_n3706_n1374# m1_n4168_2156# NAND3_62/m1_n2243_n1314# GND nfet_03v3 ad=0 pd=0 as=0 ps=0 w=508 l=56
X253 NAND3_62/m1_n3706_n1374# m1_n4168_2156# NAND3_62/m1_n2243_n1314# GND nfet_03v3 ad=0 pd=0 as=0 ps=0 w=508 l=56
X254 GND comp[1] NAND3_62/a_n593_982# GND nfet_03v3 ad=0 pd=0 as=0.10566u ps=2.448m w=508 l=56
X255 GND comp[1] NAND3_62/a_n593_982# GND nfet_03v3 ad=0 pd=0 as=0 ps=0 w=508 l=56
X256 NAND3_62/a_n593_982# comp[1] GND GND nfet_03v3 ad=0 pd=0 as=0 ps=0 w=508 l=56
X257 NAND3_62/a_n593_982# comp[1] GND GND nfet_03v3 ad=0 pd=0 as=0 ps=0 w=508 l=56
X258 GND NAND3_62/a_n593_982# NAND3_62/m1_n2243_n1314# GND nfet_03v3 ad=0 pd=0 as=0 ps=0 w=508 l=56
X259 GND NAND3_62/a_n593_982# NAND3_62/m1_n2243_n1314# GND nfet_03v3 ad=0 pd=0 as=0 ps=0 w=508 l=56
X260 NAND3_62/m1_n2243_n1314# NAND3_62/a_n593_982# GND GND nfet_03v3 ad=0 pd=0 as=0 ps=0 w=508 l=56
X261 NAND3_62/m1_n2243_n1314# NAND3_62/a_n593_982# GND GND nfet_03v3 ad=0 pd=0 as=0 ps=0 w=508 l=56
X262 NAND3_62/m1_n3706_n1374# VDD NAND3_62/a_2506_982# GND nfet_03v3 ad=0 pd=0 as=0.10566u ps=2.448m w=508 l=56
X263 NAND3_62/m1_n3706_n1374# VDD NAND3_62/a_2506_982# GND nfet_03v3 ad=0 pd=0 as=0 ps=0 w=508 l=56
X264 NAND3_62/a_2506_982# VDD NAND3_62/m1_n3706_n1374# GND nfet_03v3 ad=0 pd=0 as=0 ps=0 w=508 l=56
X265 NAND3_62/a_2506_982# VDD NAND3_62/m1_n3706_n1374# GND nfet_03v3 ad=0 pd=0 as=0 ps=0 w=508 l=56
X266 GND NAND3_62/a_2506_982# wl[0] GND nfet_03v3 ad=0 pd=0 as=0.10566u ps=2.448m w=508 l=56
X267 GND NAND3_62/a_2506_982# wl[0] GND nfet_03v3 ad=0 pd=0 as=0 ps=0 w=508 l=56
X268 wl[0] NAND3_62/a_2506_982# GND GND nfet_03v3 ad=0 pd=0 as=0 ps=0 w=508 l=56
X269 wl[0] NAND3_62/a_2506_982# GND GND nfet_03v3 ad=0 pd=0 as=0 ps=0 w=508 l=56
X270 VDD comp[33] NAND3_30/a_n593_982# VDD pfet_03v3 ad=0 pd=0 as=0.22308u ps=4.636m w=660 l=56
X271 NAND3_30/a_n593_982# comp[33] VDD VDD pfet_03v3 ad=0 pd=0 as=0 ps=0 w=660 l=56
X272 NAND3_30/a_n593_982# comp[33] VDD VDD pfet_03v3 ad=0 pd=0 as=0 ps=0 w=660 l=56
X273 VDD comp[33] NAND3_30/a_n593_982# VDD pfet_03v3 ad=0 pd=0 as=0 ps=0 w=660 l=56
X274 VDD comp[33] NAND3_30/a_n593_982# VDD pfet_03v3 ad=0 pd=0 as=0 ps=0 w=660 l=56
X275 VDD comp[32] NAND3_30/a_2506_982# VDD pfet_03v3 ad=0 pd=0 as=0.66924u ps=0.01391 w=660 l=56
X276 NAND3_30/a_2506_982# comp[32] VDD VDD pfet_03v3 ad=0 pd=0 as=0 ps=0 w=660 l=56
X277 NAND3_30/a_2506_982# comp[32] VDD VDD pfet_03v3 ad=0 pd=0 as=0 ps=0 w=660 l=56
X278 VDD comp[32] NAND3_30/a_2506_982# VDD pfet_03v3 ad=0 pd=0 as=0 ps=0 w=660 l=56
X279 VDD comp[32] NAND3_30/a_2506_982# VDD pfet_03v3 ad=0 pd=0 as=0 ps=0 w=660 l=56
X280 VDD comp[31] NAND3_30/a_2506_982# VDD pfet_03v3 ad=0 pd=0 as=0 ps=0 w=660 l=56
X281 NAND3_30/a_2506_982# comp[31] VDD VDD pfet_03v3 ad=0 pd=0 as=0 ps=0 w=660 l=56
X282 NAND3_30/a_2506_982# comp[31] VDD VDD pfet_03v3 ad=0 pd=0 as=0 ps=0 w=660 l=56
X283 VDD comp[31] NAND3_30/a_2506_982# VDD pfet_03v3 ad=0 pd=0 as=0 ps=0 w=660 l=56
X284 VDD comp[31] NAND3_30/a_2506_982# VDD pfet_03v3 ad=0 pd=0 as=0 ps=0 w=660 l=56
X285 VDD NAND3_30/a_2506_982# wl[32] VDD pfet_03v3 ad=0 pd=0 as=0.22308u ps=4.636m w=660 l=56
X286 wl[32] NAND3_30/a_2506_982# VDD VDD pfet_03v3 ad=0 pd=0 as=0 ps=0 w=660 l=56
X287 wl[32] NAND3_30/a_2506_982# VDD VDD pfet_03v3 ad=0 pd=0 as=0 ps=0 w=660 l=56
X288 VDD NAND3_30/a_2506_982# wl[32] VDD pfet_03v3 ad=0 pd=0 as=0 ps=0 w=660 l=56
X289 VDD NAND3_30/a_2506_982# wl[32] VDD pfet_03v3 ad=0 pd=0 as=0 ps=0 w=660 l=56
X290 VDD NAND3_30/a_n593_982# NAND3_30/a_2506_982# VDD pfet_03v3 ad=0 pd=0 as=0 ps=0 w=660 l=56
X291 NAND3_30/a_2506_982# NAND3_30/a_n593_982# VDD VDD pfet_03v3 ad=0 pd=0 as=0 ps=0 w=660 l=56
X292 NAND3_30/a_2506_982# NAND3_30/a_n593_982# VDD VDD pfet_03v3 ad=0 pd=0 as=0 ps=0 w=660 l=56
X293 VDD NAND3_30/a_n593_982# NAND3_30/a_2506_982# VDD pfet_03v3 ad=0 pd=0 as=0 ps=0 w=660 l=56
X294 VDD NAND3_30/a_n593_982# NAND3_30/a_2506_982# VDD pfet_03v3 ad=0 pd=0 as=0 ps=0 w=660 l=56
X295 NAND3_30/m1_n2243_n1314# comp[32] NAND3_30/m1_n3706_n1374# GND nfet_03v3 ad=0.28245u pd=6.192m as=0.28245u ps=6.192m w=508 l=56
X296 NAND3_30/m1_n2243_n1314# comp[32] NAND3_30/m1_n3706_n1374# GND nfet_03v3 ad=0 pd=0 as=0 ps=0 w=508 l=56
X297 NAND3_30/m1_n3706_n1374# comp[32] NAND3_30/m1_n2243_n1314# GND nfet_03v3 ad=0 pd=0 as=0 ps=0 w=508 l=56
X298 NAND3_30/m1_n3706_n1374# comp[32] NAND3_30/m1_n2243_n1314# GND nfet_03v3 ad=0 pd=0 as=0 ps=0 w=508 l=56
X299 GND comp[33] NAND3_30/a_n593_982# GND nfet_03v3 ad=0 pd=0 as=0.10566u ps=2.448m w=508 l=56
X300 GND comp[33] NAND3_30/a_n593_982# GND nfet_03v3 ad=0 pd=0 as=0 ps=0 w=508 l=56
X301 NAND3_30/a_n593_982# comp[33] GND GND nfet_03v3 ad=0 pd=0 as=0 ps=0 w=508 l=56
X302 NAND3_30/a_n593_982# comp[33] GND GND nfet_03v3 ad=0 pd=0 as=0 ps=0 w=508 l=56
X303 GND NAND3_30/a_n593_982# NAND3_30/m1_n2243_n1314# GND nfet_03v3 ad=0 pd=0 as=0 ps=0 w=508 l=56
X304 GND NAND3_30/a_n593_982# NAND3_30/m1_n2243_n1314# GND nfet_03v3 ad=0 pd=0 as=0 ps=0 w=508 l=56
X305 NAND3_30/m1_n2243_n1314# NAND3_30/a_n593_982# GND GND nfet_03v3 ad=0 pd=0 as=0 ps=0 w=508 l=56
X306 NAND3_30/m1_n2243_n1314# NAND3_30/a_n593_982# GND GND nfet_03v3 ad=0 pd=0 as=0 ps=0 w=508 l=56
X307 NAND3_30/m1_n3706_n1374# comp[31] NAND3_30/a_2506_982# GND nfet_03v3 ad=0 pd=0 as=0.10566u ps=2.448m w=508 l=56
X308 NAND3_30/m1_n3706_n1374# comp[31] NAND3_30/a_2506_982# GND nfet_03v3 ad=0 pd=0 as=0 ps=0 w=508 l=56
X309 NAND3_30/a_2506_982# comp[31] NAND3_30/m1_n3706_n1374# GND nfet_03v3 ad=0 pd=0 as=0 ps=0 w=508 l=56
X310 NAND3_30/a_2506_982# comp[31] NAND3_30/m1_n3706_n1374# GND nfet_03v3 ad=0 pd=0 as=0 ps=0 w=508 l=56
X311 GND NAND3_30/a_2506_982# wl[32] GND nfet_03v3 ad=0 pd=0 as=0.10566u ps=2.448m w=508 l=56
X312 GND NAND3_30/a_2506_982# wl[32] GND nfet_03v3 ad=0 pd=0 as=0 ps=0 w=508 l=56
X313 wl[32] NAND3_30/a_2506_982# GND GND nfet_03v3 ad=0 pd=0 as=0 ps=0 w=508 l=56
X314 wl[32] NAND3_30/a_2506_982# GND GND nfet_03v3 ad=0 pd=0 as=0 ps=0 w=508 l=56
X315 VDD comp[22] NAND3_41/a_n593_982# VDD pfet_03v3 ad=0 pd=0 as=0.22308u ps=4.636m w=660 l=56
X316 NAND3_41/a_n593_982# comp[22] VDD VDD pfet_03v3 ad=0 pd=0 as=0 ps=0 w=660 l=56
X317 NAND3_41/a_n593_982# comp[22] VDD VDD pfet_03v3 ad=0 pd=0 as=0 ps=0 w=660 l=56
X318 VDD comp[22] NAND3_41/a_n593_982# VDD pfet_03v3 ad=0 pd=0 as=0 ps=0 w=660 l=56
X319 VDD comp[22] NAND3_41/a_n593_982# VDD pfet_03v3 ad=0 pd=0 as=0 ps=0 w=660 l=56
X320 VDD comp[21] NAND3_41/a_2506_982# VDD pfet_03v3 ad=0 pd=0 as=0.66924u ps=0.01391 w=660 l=56
X321 NAND3_41/a_2506_982# comp[21] VDD VDD pfet_03v3 ad=0 pd=0 as=0 ps=0 w=660 l=56
X322 NAND3_41/a_2506_982# comp[21] VDD VDD pfet_03v3 ad=0 pd=0 as=0 ps=0 w=660 l=56
X323 VDD comp[21] NAND3_41/a_2506_982# VDD pfet_03v3 ad=0 pd=0 as=0 ps=0 w=660 l=56
X324 VDD comp[21] NAND3_41/a_2506_982# VDD pfet_03v3 ad=0 pd=0 as=0 ps=0 w=660 l=56
X325 VDD comp[20] NAND3_41/a_2506_982# VDD pfet_03v3 ad=0 pd=0 as=0 ps=0 w=660 l=56
X326 NAND3_41/a_2506_982# comp[20] VDD VDD pfet_03v3 ad=0 pd=0 as=0 ps=0 w=660 l=56
X327 NAND3_41/a_2506_982# comp[20] VDD VDD pfet_03v3 ad=0 pd=0 as=0 ps=0 w=660 l=56
X328 VDD comp[20] NAND3_41/a_2506_982# VDD pfet_03v3 ad=0 pd=0 as=0 ps=0 w=660 l=56
X329 VDD comp[20] NAND3_41/a_2506_982# VDD pfet_03v3 ad=0 pd=0 as=0 ps=0 w=660 l=56
X330 VDD NAND3_41/a_2506_982# wl[21] VDD pfet_03v3 ad=0 pd=0 as=0.22308u ps=4.636m w=660 l=56
X331 wl[21] NAND3_41/a_2506_982# VDD VDD pfet_03v3 ad=0 pd=0 as=0 ps=0 w=660 l=56
X332 wl[21] NAND3_41/a_2506_982# VDD VDD pfet_03v3 ad=0 pd=0 as=0 ps=0 w=660 l=56
X333 VDD NAND3_41/a_2506_982# wl[21] VDD pfet_03v3 ad=0 pd=0 as=0 ps=0 w=660 l=56
X334 VDD NAND3_41/a_2506_982# wl[21] VDD pfet_03v3 ad=0 pd=0 as=0 ps=0 w=660 l=56
X335 VDD NAND3_41/a_n593_982# NAND3_41/a_2506_982# VDD pfet_03v3 ad=0 pd=0 as=0 ps=0 w=660 l=56
X336 NAND3_41/a_2506_982# NAND3_41/a_n593_982# VDD VDD pfet_03v3 ad=0 pd=0 as=0 ps=0 w=660 l=56
X337 NAND3_41/a_2506_982# NAND3_41/a_n593_982# VDD VDD pfet_03v3 ad=0 pd=0 as=0 ps=0 w=660 l=56
X338 VDD NAND3_41/a_n593_982# NAND3_41/a_2506_982# VDD pfet_03v3 ad=0 pd=0 as=0 ps=0 w=660 l=56
X339 VDD NAND3_41/a_n593_982# NAND3_41/a_2506_982# VDD pfet_03v3 ad=0 pd=0 as=0 ps=0 w=660 l=56
X340 NAND3_41/m1_n2243_n1314# comp[21] NAND3_41/m1_n3706_n1374# GND nfet_03v3 ad=0.28245u pd=6.192m as=0.28245u ps=6.192m w=508 l=56
X341 NAND3_41/m1_n2243_n1314# comp[21] NAND3_41/m1_n3706_n1374# GND nfet_03v3 ad=0 pd=0 as=0 ps=0 w=508 l=56
X342 NAND3_41/m1_n3706_n1374# comp[21] NAND3_41/m1_n2243_n1314# GND nfet_03v3 ad=0 pd=0 as=0 ps=0 w=508 l=56
X343 NAND3_41/m1_n3706_n1374# comp[21] NAND3_41/m1_n2243_n1314# GND nfet_03v3 ad=0 pd=0 as=0 ps=0 w=508 l=56
X344 GND comp[22] NAND3_41/a_n593_982# GND nfet_03v3 ad=0 pd=0 as=0.10566u ps=2.448m w=508 l=56
X345 GND comp[22] NAND3_41/a_n593_982# GND nfet_03v3 ad=0 pd=0 as=0 ps=0 w=508 l=56
X346 NAND3_41/a_n593_982# comp[22] GND GND nfet_03v3 ad=0 pd=0 as=0 ps=0 w=508 l=56
X347 NAND3_41/a_n593_982# comp[22] GND GND nfet_03v3 ad=0 pd=0 as=0 ps=0 w=508 l=56
X348 GND NAND3_41/a_n593_982# NAND3_41/m1_n2243_n1314# GND nfet_03v3 ad=0 pd=0 as=0 ps=0 w=508 l=56
X349 GND NAND3_41/a_n593_982# NAND3_41/m1_n2243_n1314# GND nfet_03v3 ad=0 pd=0 as=0 ps=0 w=508 l=56
X350 NAND3_41/m1_n2243_n1314# NAND3_41/a_n593_982# GND GND nfet_03v3 ad=0 pd=0 as=0 ps=0 w=508 l=56
X351 NAND3_41/m1_n2243_n1314# NAND3_41/a_n593_982# GND GND nfet_03v3 ad=0 pd=0 as=0 ps=0 w=508 l=56
X352 NAND3_41/m1_n3706_n1374# comp[20] NAND3_41/a_2506_982# GND nfet_03v3 ad=0 pd=0 as=0.10566u ps=2.448m w=508 l=56
X353 NAND3_41/m1_n3706_n1374# comp[20] NAND3_41/a_2506_982# GND nfet_03v3 ad=0 pd=0 as=0 ps=0 w=508 l=56
X354 NAND3_41/a_2506_982# comp[20] NAND3_41/m1_n3706_n1374# GND nfet_03v3 ad=0 pd=0 as=0 ps=0 w=508 l=56
X355 NAND3_41/a_2506_982# comp[20] NAND3_41/m1_n3706_n1374# GND nfet_03v3 ad=0 pd=0 as=0 ps=0 w=508 l=56
X356 GND NAND3_41/a_2506_982# wl[21] GND nfet_03v3 ad=0 pd=0 as=0.10566u ps=2.448m w=508 l=56
X357 GND NAND3_41/a_2506_982# wl[21] GND nfet_03v3 ad=0 pd=0 as=0 ps=0 w=508 l=56
X358 wl[21] NAND3_41/a_2506_982# GND GND nfet_03v3 ad=0 pd=0 as=0 ps=0 w=508 l=56
X359 wl[21] NAND3_41/a_2506_982# GND GND nfet_03v3 ad=0 pd=0 as=0 ps=0 w=508 l=56
X360 VDD comp[11] NAND3_52/a_n593_982# VDD pfet_03v3 ad=0 pd=0 as=0.22308u ps=4.636m w=660 l=56
X361 NAND3_52/a_n593_982# comp[11] VDD VDD pfet_03v3 ad=0 pd=0 as=0 ps=0 w=660 l=56
X362 NAND3_52/a_n593_982# comp[11] VDD VDD pfet_03v3 ad=0 pd=0 as=0 ps=0 w=660 l=56
X363 VDD comp[11] NAND3_52/a_n593_982# VDD pfet_03v3 ad=0 pd=0 as=0 ps=0 w=660 l=56
X364 VDD comp[11] NAND3_52/a_n593_982# VDD pfet_03v3 ad=0 pd=0 as=0 ps=0 w=660 l=56
X365 VDD comp[10] NAND3_52/a_2506_982# VDD pfet_03v3 ad=0 pd=0 as=0.66924u ps=0.01391 w=660 l=56
X366 NAND3_52/a_2506_982# comp[10] VDD VDD pfet_03v3 ad=0 pd=0 as=0 ps=0 w=660 l=56
X367 NAND3_52/a_2506_982# comp[10] VDD VDD pfet_03v3 ad=0 pd=0 as=0 ps=0 w=660 l=56
X368 VDD comp[10] NAND3_52/a_2506_982# VDD pfet_03v3 ad=0 pd=0 as=0 ps=0 w=660 l=56
X369 VDD comp[10] NAND3_52/a_2506_982# VDD pfet_03v3 ad=0 pd=0 as=0 ps=0 w=660 l=56
X370 VDD comp[9] NAND3_52/a_2506_982# VDD pfet_03v3 ad=0 pd=0 as=0 ps=0 w=660 l=56
X371 NAND3_52/a_2506_982# comp[9] VDD VDD pfet_03v3 ad=0 pd=0 as=0 ps=0 w=660 l=56
X372 NAND3_52/a_2506_982# comp[9] VDD VDD pfet_03v3 ad=0 pd=0 as=0 ps=0 w=660 l=56
X373 VDD comp[9] NAND3_52/a_2506_982# VDD pfet_03v3 ad=0 pd=0 as=0 ps=0 w=660 l=56
X374 VDD comp[9] NAND3_52/a_2506_982# VDD pfet_03v3 ad=0 pd=0 as=0 ps=0 w=660 l=56
X375 VDD NAND3_52/a_2506_982# wl[10] VDD pfet_03v3 ad=0 pd=0 as=0.22308u ps=4.636m w=660 l=56
X376 wl[10] NAND3_52/a_2506_982# VDD VDD pfet_03v3 ad=0 pd=0 as=0 ps=0 w=660 l=56
X377 wl[10] NAND3_52/a_2506_982# VDD VDD pfet_03v3 ad=0 pd=0 as=0 ps=0 w=660 l=56
X378 VDD NAND3_52/a_2506_982# wl[10] VDD pfet_03v3 ad=0 pd=0 as=0 ps=0 w=660 l=56
X379 VDD NAND3_52/a_2506_982# wl[10] VDD pfet_03v3 ad=0 pd=0 as=0 ps=0 w=660 l=56
X380 VDD NAND3_52/a_n593_982# NAND3_52/a_2506_982# VDD pfet_03v3 ad=0 pd=0 as=0 ps=0 w=660 l=56
X381 NAND3_52/a_2506_982# NAND3_52/a_n593_982# VDD VDD pfet_03v3 ad=0 pd=0 as=0 ps=0 w=660 l=56
X382 NAND3_52/a_2506_982# NAND3_52/a_n593_982# VDD VDD pfet_03v3 ad=0 pd=0 as=0 ps=0 w=660 l=56
X383 VDD NAND3_52/a_n593_982# NAND3_52/a_2506_982# VDD pfet_03v3 ad=0 pd=0 as=0 ps=0 w=660 l=56
X384 VDD NAND3_52/a_n593_982# NAND3_52/a_2506_982# VDD pfet_03v3 ad=0 pd=0 as=0 ps=0 w=660 l=56
X385 NAND3_52/m1_n2243_n1314# comp[10] NAND3_52/m1_n3706_n1374# GND nfet_03v3 ad=0.28245u pd=6.192m as=0.28245u ps=6.192m w=508 l=56
X386 NAND3_52/m1_n2243_n1314# comp[10] NAND3_52/m1_n3706_n1374# GND nfet_03v3 ad=0 pd=0 as=0 ps=0 w=508 l=56
X387 NAND3_52/m1_n3706_n1374# comp[10] NAND3_52/m1_n2243_n1314# GND nfet_03v3 ad=0 pd=0 as=0 ps=0 w=508 l=56
X388 NAND3_52/m1_n3706_n1374# comp[10] NAND3_52/m1_n2243_n1314# GND nfet_03v3 ad=0 pd=0 as=0 ps=0 w=508 l=56
X389 GND comp[11] NAND3_52/a_n593_982# GND nfet_03v3 ad=0 pd=0 as=0.10566u ps=2.448m w=508 l=56
X390 GND comp[11] NAND3_52/a_n593_982# GND nfet_03v3 ad=0 pd=0 as=0 ps=0 w=508 l=56
X391 NAND3_52/a_n593_982# comp[11] GND GND nfet_03v3 ad=0 pd=0 as=0 ps=0 w=508 l=56
X392 NAND3_52/a_n593_982# comp[11] GND GND nfet_03v3 ad=0 pd=0 as=0 ps=0 w=508 l=56
X393 GND NAND3_52/a_n593_982# NAND3_52/m1_n2243_n1314# GND nfet_03v3 ad=0 pd=0 as=0 ps=0 w=508 l=56
X394 GND NAND3_52/a_n593_982# NAND3_52/m1_n2243_n1314# GND nfet_03v3 ad=0 pd=0 as=0 ps=0 w=508 l=56
X395 NAND3_52/m1_n2243_n1314# NAND3_52/a_n593_982# GND GND nfet_03v3 ad=0 pd=0 as=0 ps=0 w=508 l=56
X396 NAND3_52/m1_n2243_n1314# NAND3_52/a_n593_982# GND GND nfet_03v3 ad=0 pd=0 as=0 ps=0 w=508 l=56
X397 NAND3_52/m1_n3706_n1374# comp[9] NAND3_52/a_2506_982# GND nfet_03v3 ad=0 pd=0 as=0.10566u ps=2.448m w=508 l=56
X398 NAND3_52/m1_n3706_n1374# comp[9] NAND3_52/a_2506_982# GND nfet_03v3 ad=0 pd=0 as=0 ps=0 w=508 l=56
X399 NAND3_52/a_2506_982# comp[9] NAND3_52/m1_n3706_n1374# GND nfet_03v3 ad=0 pd=0 as=0 ps=0 w=508 l=56
X400 NAND3_52/a_2506_982# comp[9] NAND3_52/m1_n3706_n1374# GND nfet_03v3 ad=0 pd=0 as=0 ps=0 w=508 l=56
X401 GND NAND3_52/a_2506_982# wl[10] GND nfet_03v3 ad=0 pd=0 as=0.10566u ps=2.448m w=508 l=56
X402 GND NAND3_52/a_2506_982# wl[10] GND nfet_03v3 ad=0 pd=0 as=0 ps=0 w=508 l=56
X403 wl[10] NAND3_52/a_2506_982# GND GND nfet_03v3 ad=0 pd=0 as=0 ps=0 w=508 l=56
X404 wl[10] NAND3_52/a_2506_982# GND GND nfet_03v3 ad=0 pd=0 as=0 ps=0 w=508 l=56
X405 VDD comp[43] NAND3_20/a_n593_982# VDD pfet_03v3 ad=0 pd=0 as=0.22308u ps=4.636m w=660 l=56
X406 NAND3_20/a_n593_982# comp[43] VDD VDD pfet_03v3 ad=0 pd=0 as=0 ps=0 w=660 l=56
X407 NAND3_20/a_n593_982# comp[43] VDD VDD pfet_03v3 ad=0 pd=0 as=0 ps=0 w=660 l=56
X408 VDD comp[43] NAND3_20/a_n593_982# VDD pfet_03v3 ad=0 pd=0 as=0 ps=0 w=660 l=56
X409 VDD comp[43] NAND3_20/a_n593_982# VDD pfet_03v3 ad=0 pd=0 as=0 ps=0 w=660 l=56
X410 VDD comp[42] NAND3_20/a_2506_982# VDD pfet_03v3 ad=0 pd=0 as=0.66924u ps=0.01391 w=660 l=56
X411 NAND3_20/a_2506_982# comp[42] VDD VDD pfet_03v3 ad=0 pd=0 as=0 ps=0 w=660 l=56
X412 NAND3_20/a_2506_982# comp[42] VDD VDD pfet_03v3 ad=0 pd=0 as=0 ps=0 w=660 l=56
X413 VDD comp[42] NAND3_20/a_2506_982# VDD pfet_03v3 ad=0 pd=0 as=0 ps=0 w=660 l=56
X414 VDD comp[42] NAND3_20/a_2506_982# VDD pfet_03v3 ad=0 pd=0 as=0 ps=0 w=660 l=56
X415 VDD comp[41] NAND3_20/a_2506_982# VDD pfet_03v3 ad=0 pd=0 as=0 ps=0 w=660 l=56
X416 NAND3_20/a_2506_982# comp[41] VDD VDD pfet_03v3 ad=0 pd=0 as=0 ps=0 w=660 l=56
X417 NAND3_20/a_2506_982# comp[41] VDD VDD pfet_03v3 ad=0 pd=0 as=0 ps=0 w=660 l=56
X418 VDD comp[41] NAND3_20/a_2506_982# VDD pfet_03v3 ad=0 pd=0 as=0 ps=0 w=660 l=56
X419 VDD comp[41] NAND3_20/a_2506_982# VDD pfet_03v3 ad=0 pd=0 as=0 ps=0 w=660 l=56
X420 VDD NAND3_20/a_2506_982# wl[42] VDD pfet_03v3 ad=0 pd=0 as=0.22308u ps=4.636m w=660 l=56
X421 wl[42] NAND3_20/a_2506_982# VDD VDD pfet_03v3 ad=0 pd=0 as=0 ps=0 w=660 l=56
X422 wl[42] NAND3_20/a_2506_982# VDD VDD pfet_03v3 ad=0 pd=0 as=0 ps=0 w=660 l=56
X423 VDD NAND3_20/a_2506_982# wl[42] VDD pfet_03v3 ad=0 pd=0 as=0 ps=0 w=660 l=56
X424 VDD NAND3_20/a_2506_982# wl[42] VDD pfet_03v3 ad=0 pd=0 as=0 ps=0 w=660 l=56
X425 VDD NAND3_20/a_n593_982# NAND3_20/a_2506_982# VDD pfet_03v3 ad=0 pd=0 as=0 ps=0 w=660 l=56
X426 NAND3_20/a_2506_982# NAND3_20/a_n593_982# VDD VDD pfet_03v3 ad=0 pd=0 as=0 ps=0 w=660 l=56
X427 NAND3_20/a_2506_982# NAND3_20/a_n593_982# VDD VDD pfet_03v3 ad=0 pd=0 as=0 ps=0 w=660 l=56
X428 VDD NAND3_20/a_n593_982# NAND3_20/a_2506_982# VDD pfet_03v3 ad=0 pd=0 as=0 ps=0 w=660 l=56
X429 VDD NAND3_20/a_n593_982# NAND3_20/a_2506_982# VDD pfet_03v3 ad=0 pd=0 as=0 ps=0 w=660 l=56
X430 NAND3_20/m1_n2243_n1314# comp[42] NAND3_20/m1_n3706_n1374# GND nfet_03v3 ad=0.28245u pd=6.192m as=0.28245u ps=6.192m w=508 l=56
X431 NAND3_20/m1_n2243_n1314# comp[42] NAND3_20/m1_n3706_n1374# GND nfet_03v3 ad=0 pd=0 as=0 ps=0 w=508 l=56
X432 NAND3_20/m1_n3706_n1374# comp[42] NAND3_20/m1_n2243_n1314# GND nfet_03v3 ad=0 pd=0 as=0 ps=0 w=508 l=56
X433 NAND3_20/m1_n3706_n1374# comp[42] NAND3_20/m1_n2243_n1314# GND nfet_03v3 ad=0 pd=0 as=0 ps=0 w=508 l=56
X434 GND comp[43] NAND3_20/a_n593_982# GND nfet_03v3 ad=0 pd=0 as=0.10566u ps=2.448m w=508 l=56
X435 GND comp[43] NAND3_20/a_n593_982# GND nfet_03v3 ad=0 pd=0 as=0 ps=0 w=508 l=56
X436 NAND3_20/a_n593_982# comp[43] GND GND nfet_03v3 ad=0 pd=0 as=0 ps=0 w=508 l=56
X437 NAND3_20/a_n593_982# comp[43] GND GND nfet_03v3 ad=0 pd=0 as=0 ps=0 w=508 l=56
X438 GND NAND3_20/a_n593_982# NAND3_20/m1_n2243_n1314# GND nfet_03v3 ad=0 pd=0 as=0 ps=0 w=508 l=56
X439 GND NAND3_20/a_n593_982# NAND3_20/m1_n2243_n1314# GND nfet_03v3 ad=0 pd=0 as=0 ps=0 w=508 l=56
X440 NAND3_20/m1_n2243_n1314# NAND3_20/a_n593_982# GND GND nfet_03v3 ad=0 pd=0 as=0 ps=0 w=508 l=56
X441 NAND3_20/m1_n2243_n1314# NAND3_20/a_n593_982# GND GND nfet_03v3 ad=0 pd=0 as=0 ps=0 w=508 l=56
X442 NAND3_20/m1_n3706_n1374# comp[41] NAND3_20/a_2506_982# GND nfet_03v3 ad=0 pd=0 as=0.10566u ps=2.448m w=508 l=56
X443 NAND3_20/m1_n3706_n1374# comp[41] NAND3_20/a_2506_982# GND nfet_03v3 ad=0 pd=0 as=0 ps=0 w=508 l=56
X444 NAND3_20/a_2506_982# comp[41] NAND3_20/m1_n3706_n1374# GND nfet_03v3 ad=0 pd=0 as=0 ps=0 w=508 l=56
X445 NAND3_20/a_2506_982# comp[41] NAND3_20/m1_n3706_n1374# GND nfet_03v3 ad=0 pd=0 as=0 ps=0 w=508 l=56
X446 GND NAND3_20/a_2506_982# wl[42] GND nfet_03v3 ad=0 pd=0 as=0.10566u ps=2.448m w=508 l=56
X447 GND NAND3_20/a_2506_982# wl[42] GND nfet_03v3 ad=0 pd=0 as=0 ps=0 w=508 l=56
X448 wl[42] NAND3_20/a_2506_982# GND GND nfet_03v3 ad=0 pd=0 as=0 ps=0 w=508 l=56
X449 wl[42] NAND3_20/a_2506_982# GND GND nfet_03v3 ad=0 pd=0 as=0 ps=0 w=508 l=56
X450 VDD comp[32] NAND3_31/a_n593_982# VDD pfet_03v3 ad=0 pd=0 as=0.22308u ps=4.636m w=660 l=56
X451 NAND3_31/a_n593_982# comp[32] VDD VDD pfet_03v3 ad=0 pd=0 as=0 ps=0 w=660 l=56
X452 NAND3_31/a_n593_982# comp[32] VDD VDD pfet_03v3 ad=0 pd=0 as=0 ps=0 w=660 l=56
X453 VDD comp[32] NAND3_31/a_n593_982# VDD pfet_03v3 ad=0 pd=0 as=0 ps=0 w=660 l=56
X454 VDD comp[32] NAND3_31/a_n593_982# VDD pfet_03v3 ad=0 pd=0 as=0 ps=0 w=660 l=56
X455 VDD comp[31] NAND3_31/a_2506_982# VDD pfet_03v3 ad=0 pd=0 as=0.66924u ps=0.01391 w=660 l=56
X456 NAND3_31/a_2506_982# comp[31] VDD VDD pfet_03v3 ad=0 pd=0 as=0 ps=0 w=660 l=56
X457 NAND3_31/a_2506_982# comp[31] VDD VDD pfet_03v3 ad=0 pd=0 as=0 ps=0 w=660 l=56
X458 VDD comp[31] NAND3_31/a_2506_982# VDD pfet_03v3 ad=0 pd=0 as=0 ps=0 w=660 l=56
X459 VDD comp[31] NAND3_31/a_2506_982# VDD pfet_03v3 ad=0 pd=0 as=0 ps=0 w=660 l=56
X460 VDD comp[30] NAND3_31/a_2506_982# VDD pfet_03v3 ad=0 pd=0 as=0 ps=0 w=660 l=56
X461 NAND3_31/a_2506_982# comp[30] VDD VDD pfet_03v3 ad=0 pd=0 as=0 ps=0 w=660 l=56
X462 NAND3_31/a_2506_982# comp[30] VDD VDD pfet_03v3 ad=0 pd=0 as=0 ps=0 w=660 l=56
X463 VDD comp[30] NAND3_31/a_2506_982# VDD pfet_03v3 ad=0 pd=0 as=0 ps=0 w=660 l=56
X464 VDD comp[30] NAND3_31/a_2506_982# VDD pfet_03v3 ad=0 pd=0 as=0 ps=0 w=660 l=56
X465 VDD NAND3_31/a_2506_982# wl[31] VDD pfet_03v3 ad=0 pd=0 as=0.22308u ps=4.636m w=660 l=56
X466 wl[31] NAND3_31/a_2506_982# VDD VDD pfet_03v3 ad=0 pd=0 as=0 ps=0 w=660 l=56
X467 wl[31] NAND3_31/a_2506_982# VDD VDD pfet_03v3 ad=0 pd=0 as=0 ps=0 w=660 l=56
X468 VDD NAND3_31/a_2506_982# wl[31] VDD pfet_03v3 ad=0 pd=0 as=0 ps=0 w=660 l=56
X469 VDD NAND3_31/a_2506_982# wl[31] VDD pfet_03v3 ad=0 pd=0 as=0 ps=0 w=660 l=56
X470 VDD NAND3_31/a_n593_982# NAND3_31/a_2506_982# VDD pfet_03v3 ad=0 pd=0 as=0 ps=0 w=660 l=56
X471 NAND3_31/a_2506_982# NAND3_31/a_n593_982# VDD VDD pfet_03v3 ad=0 pd=0 as=0 ps=0 w=660 l=56
X472 NAND3_31/a_2506_982# NAND3_31/a_n593_982# VDD VDD pfet_03v3 ad=0 pd=0 as=0 ps=0 w=660 l=56
X473 VDD NAND3_31/a_n593_982# NAND3_31/a_2506_982# VDD pfet_03v3 ad=0 pd=0 as=0 ps=0 w=660 l=56
X474 VDD NAND3_31/a_n593_982# NAND3_31/a_2506_982# VDD pfet_03v3 ad=0 pd=0 as=0 ps=0 w=660 l=56
X475 NAND3_31/m1_n2243_n1314# comp[31] NAND3_31/m1_n3706_n1374# GND nfet_03v3 ad=0.28245u pd=6.192m as=0.28245u ps=6.192m w=508 l=56
X476 NAND3_31/m1_n2243_n1314# comp[31] NAND3_31/m1_n3706_n1374# GND nfet_03v3 ad=0 pd=0 as=0 ps=0 w=508 l=56
X477 NAND3_31/m1_n3706_n1374# comp[31] NAND3_31/m1_n2243_n1314# GND nfet_03v3 ad=0 pd=0 as=0 ps=0 w=508 l=56
X478 NAND3_31/m1_n3706_n1374# comp[31] NAND3_31/m1_n2243_n1314# GND nfet_03v3 ad=0 pd=0 as=0 ps=0 w=508 l=56
X479 GND comp[32] NAND3_31/a_n593_982# GND nfet_03v3 ad=0 pd=0 as=0.10566u ps=2.448m w=508 l=56
X480 GND comp[32] NAND3_31/a_n593_982# GND nfet_03v3 ad=0 pd=0 as=0 ps=0 w=508 l=56
X481 NAND3_31/a_n593_982# comp[32] GND GND nfet_03v3 ad=0 pd=0 as=0 ps=0 w=508 l=56
X482 NAND3_31/a_n593_982# comp[32] GND GND nfet_03v3 ad=0 pd=0 as=0 ps=0 w=508 l=56
X483 GND NAND3_31/a_n593_982# NAND3_31/m1_n2243_n1314# GND nfet_03v3 ad=0 pd=0 as=0 ps=0 w=508 l=56
X484 GND NAND3_31/a_n593_982# NAND3_31/m1_n2243_n1314# GND nfet_03v3 ad=0 pd=0 as=0 ps=0 w=508 l=56
X485 NAND3_31/m1_n2243_n1314# NAND3_31/a_n593_982# GND GND nfet_03v3 ad=0 pd=0 as=0 ps=0 w=508 l=56
X486 NAND3_31/m1_n2243_n1314# NAND3_31/a_n593_982# GND GND nfet_03v3 ad=0 pd=0 as=0 ps=0 w=508 l=56
X487 NAND3_31/m1_n3706_n1374# comp[30] NAND3_31/a_2506_982# GND nfet_03v3 ad=0 pd=0 as=0.10566u ps=2.448m w=508 l=56
X488 NAND3_31/m1_n3706_n1374# comp[30] NAND3_31/a_2506_982# GND nfet_03v3 ad=0 pd=0 as=0 ps=0 w=508 l=56
X489 NAND3_31/a_2506_982# comp[30] NAND3_31/m1_n3706_n1374# GND nfet_03v3 ad=0 pd=0 as=0 ps=0 w=508 l=56
X490 NAND3_31/a_2506_982# comp[30] NAND3_31/m1_n3706_n1374# GND nfet_03v3 ad=0 pd=0 as=0 ps=0 w=508 l=56
X491 GND NAND3_31/a_2506_982# wl[31] GND nfet_03v3 ad=0 pd=0 as=0.10566u ps=2.448m w=508 l=56
X492 GND NAND3_31/a_2506_982# wl[31] GND nfet_03v3 ad=0 pd=0 as=0 ps=0 w=508 l=56
X493 wl[31] NAND3_31/a_2506_982# GND GND nfet_03v3 ad=0 pd=0 as=0 ps=0 w=508 l=56
X494 wl[31] NAND3_31/a_2506_982# GND GND nfet_03v3 ad=0 pd=0 as=0 ps=0 w=508 l=56
X495 VDD comp[21] NAND3_42/a_n593_982# VDD pfet_03v3 ad=0 pd=0 as=0.22308u ps=4.636m w=660 l=56
X496 NAND3_42/a_n593_982# comp[21] VDD VDD pfet_03v3 ad=0 pd=0 as=0 ps=0 w=660 l=56
X497 NAND3_42/a_n593_982# comp[21] VDD VDD pfet_03v3 ad=0 pd=0 as=0 ps=0 w=660 l=56
X498 VDD comp[21] NAND3_42/a_n593_982# VDD pfet_03v3 ad=0 pd=0 as=0 ps=0 w=660 l=56
X499 VDD comp[21] NAND3_42/a_n593_982# VDD pfet_03v3 ad=0 pd=0 as=0 ps=0 w=660 l=56
X500 VDD comp[20] NAND3_42/a_2506_982# VDD pfet_03v3 ad=0 pd=0 as=0.66924u ps=0.01391 w=660 l=56
X501 NAND3_42/a_2506_982# comp[20] VDD VDD pfet_03v3 ad=0 pd=0 as=0 ps=0 w=660 l=56
X502 NAND3_42/a_2506_982# comp[20] VDD VDD pfet_03v3 ad=0 pd=0 as=0 ps=0 w=660 l=56
X503 VDD comp[20] NAND3_42/a_2506_982# VDD pfet_03v3 ad=0 pd=0 as=0 ps=0 w=660 l=56
X504 VDD comp[20] NAND3_42/a_2506_982# VDD pfet_03v3 ad=0 pd=0 as=0 ps=0 w=660 l=56
X505 VDD comp[19] NAND3_42/a_2506_982# VDD pfet_03v3 ad=0 pd=0 as=0 ps=0 w=660 l=56
X506 NAND3_42/a_2506_982# comp[19] VDD VDD pfet_03v3 ad=0 pd=0 as=0 ps=0 w=660 l=56
X507 NAND3_42/a_2506_982# comp[19] VDD VDD pfet_03v3 ad=0 pd=0 as=0 ps=0 w=660 l=56
X508 VDD comp[19] NAND3_42/a_2506_982# VDD pfet_03v3 ad=0 pd=0 as=0 ps=0 w=660 l=56
X509 VDD comp[19] NAND3_42/a_2506_982# VDD pfet_03v3 ad=0 pd=0 as=0 ps=0 w=660 l=56
X510 VDD NAND3_42/a_2506_982# wl[20] VDD pfet_03v3 ad=0 pd=0 as=0.22308u ps=4.636m w=660 l=56
X511 wl[20] NAND3_42/a_2506_982# VDD VDD pfet_03v3 ad=0 pd=0 as=0 ps=0 w=660 l=56
X512 wl[20] NAND3_42/a_2506_982# VDD VDD pfet_03v3 ad=0 pd=0 as=0 ps=0 w=660 l=56
X513 VDD NAND3_42/a_2506_982# wl[20] VDD pfet_03v3 ad=0 pd=0 as=0 ps=0 w=660 l=56
X514 VDD NAND3_42/a_2506_982# wl[20] VDD pfet_03v3 ad=0 pd=0 as=0 ps=0 w=660 l=56
X515 VDD NAND3_42/a_n593_982# NAND3_42/a_2506_982# VDD pfet_03v3 ad=0 pd=0 as=0 ps=0 w=660 l=56
X516 NAND3_42/a_2506_982# NAND3_42/a_n593_982# VDD VDD pfet_03v3 ad=0 pd=0 as=0 ps=0 w=660 l=56
X517 NAND3_42/a_2506_982# NAND3_42/a_n593_982# VDD VDD pfet_03v3 ad=0 pd=0 as=0 ps=0 w=660 l=56
X518 VDD NAND3_42/a_n593_982# NAND3_42/a_2506_982# VDD pfet_03v3 ad=0 pd=0 as=0 ps=0 w=660 l=56
X519 VDD NAND3_42/a_n593_982# NAND3_42/a_2506_982# VDD pfet_03v3 ad=0 pd=0 as=0 ps=0 w=660 l=56
X520 NAND3_42/m1_n2243_n1314# comp[20] NAND3_42/m1_n3706_n1374# GND nfet_03v3 ad=0.28245u pd=6.192m as=0.28245u ps=6.192m w=508 l=56
X521 NAND3_42/m1_n2243_n1314# comp[20] NAND3_42/m1_n3706_n1374# GND nfet_03v3 ad=0 pd=0 as=0 ps=0 w=508 l=56
X522 NAND3_42/m1_n3706_n1374# comp[20] NAND3_42/m1_n2243_n1314# GND nfet_03v3 ad=0 pd=0 as=0 ps=0 w=508 l=56
X523 NAND3_42/m1_n3706_n1374# comp[20] NAND3_42/m1_n2243_n1314# GND nfet_03v3 ad=0 pd=0 as=0 ps=0 w=508 l=56
X524 GND comp[21] NAND3_42/a_n593_982# GND nfet_03v3 ad=0 pd=0 as=0.10566u ps=2.448m w=508 l=56
X525 GND comp[21] NAND3_42/a_n593_982# GND nfet_03v3 ad=0 pd=0 as=0 ps=0 w=508 l=56
X526 NAND3_42/a_n593_982# comp[21] GND GND nfet_03v3 ad=0 pd=0 as=0 ps=0 w=508 l=56
X527 NAND3_42/a_n593_982# comp[21] GND GND nfet_03v3 ad=0 pd=0 as=0 ps=0 w=508 l=56
X528 GND NAND3_42/a_n593_982# NAND3_42/m1_n2243_n1314# GND nfet_03v3 ad=0 pd=0 as=0 ps=0 w=508 l=56
X529 GND NAND3_42/a_n593_982# NAND3_42/m1_n2243_n1314# GND nfet_03v3 ad=0 pd=0 as=0 ps=0 w=508 l=56
X530 NAND3_42/m1_n2243_n1314# NAND3_42/a_n593_982# GND GND nfet_03v3 ad=0 pd=0 as=0 ps=0 w=508 l=56
X531 NAND3_42/m1_n2243_n1314# NAND3_42/a_n593_982# GND GND nfet_03v3 ad=0 pd=0 as=0 ps=0 w=508 l=56
X532 NAND3_42/m1_n3706_n1374# comp[19] NAND3_42/a_2506_982# GND nfet_03v3 ad=0 pd=0 as=0.10566u ps=2.448m w=508 l=56
X533 NAND3_42/m1_n3706_n1374# comp[19] NAND3_42/a_2506_982# GND nfet_03v3 ad=0 pd=0 as=0 ps=0 w=508 l=56
X534 NAND3_42/a_2506_982# comp[19] NAND3_42/m1_n3706_n1374# GND nfet_03v3 ad=0 pd=0 as=0 ps=0 w=508 l=56
X535 NAND3_42/a_2506_982# comp[19] NAND3_42/m1_n3706_n1374# GND nfet_03v3 ad=0 pd=0 as=0 ps=0 w=508 l=56
X536 GND NAND3_42/a_2506_982# wl[20] GND nfet_03v3 ad=0 pd=0 as=0.10566u ps=2.448m w=508 l=56
X537 GND NAND3_42/a_2506_982# wl[20] GND nfet_03v3 ad=0 pd=0 as=0 ps=0 w=508 l=56
X538 wl[20] NAND3_42/a_2506_982# GND GND nfet_03v3 ad=0 pd=0 as=0 ps=0 w=508 l=56
X539 wl[20] NAND3_42/a_2506_982# GND GND nfet_03v3 ad=0 pd=0 as=0 ps=0 w=508 l=56
X540 VDD comp[10] NAND3_53/a_n593_982# VDD pfet_03v3 ad=0 pd=0 as=0.22308u ps=4.636m w=660 l=56
X541 NAND3_53/a_n593_982# comp[10] VDD VDD pfet_03v3 ad=0 pd=0 as=0 ps=0 w=660 l=56
X542 NAND3_53/a_n593_982# comp[10] VDD VDD pfet_03v3 ad=0 pd=0 as=0 ps=0 w=660 l=56
X543 VDD comp[10] NAND3_53/a_n593_982# VDD pfet_03v3 ad=0 pd=0 as=0 ps=0 w=660 l=56
X544 VDD comp[10] NAND3_53/a_n593_982# VDD pfet_03v3 ad=0 pd=0 as=0 ps=0 w=660 l=56
X545 VDD comp[9] NAND3_53/a_2506_982# VDD pfet_03v3 ad=0 pd=0 as=0.66924u ps=0.01391 w=660 l=56
X546 NAND3_53/a_2506_982# comp[9] VDD VDD pfet_03v3 ad=0 pd=0 as=0 ps=0 w=660 l=56
X547 NAND3_53/a_2506_982# comp[9] VDD VDD pfet_03v3 ad=0 pd=0 as=0 ps=0 w=660 l=56
X548 VDD comp[9] NAND3_53/a_2506_982# VDD pfet_03v3 ad=0 pd=0 as=0 ps=0 w=660 l=56
X549 VDD comp[9] NAND3_53/a_2506_982# VDD pfet_03v3 ad=0 pd=0 as=0 ps=0 w=660 l=56
X550 VDD comp[8] NAND3_53/a_2506_982# VDD pfet_03v3 ad=0 pd=0 as=0 ps=0 w=660 l=56
X551 NAND3_53/a_2506_982# comp[8] VDD VDD pfet_03v3 ad=0 pd=0 as=0 ps=0 w=660 l=56
X552 NAND3_53/a_2506_982# comp[8] VDD VDD pfet_03v3 ad=0 pd=0 as=0 ps=0 w=660 l=56
X553 VDD comp[8] NAND3_53/a_2506_982# VDD pfet_03v3 ad=0 pd=0 as=0 ps=0 w=660 l=56
X554 VDD comp[8] NAND3_53/a_2506_982# VDD pfet_03v3 ad=0 pd=0 as=0 ps=0 w=660 l=56
X555 VDD NAND3_53/a_2506_982# wl[9] VDD pfet_03v3 ad=0 pd=0 as=0.22308u ps=4.636m w=660 l=56
X556 wl[9] NAND3_53/a_2506_982# VDD VDD pfet_03v3 ad=0 pd=0 as=0 ps=0 w=660 l=56
X557 wl[9] NAND3_53/a_2506_982# VDD VDD pfet_03v3 ad=0 pd=0 as=0 ps=0 w=660 l=56
X558 VDD NAND3_53/a_2506_982# wl[9] VDD pfet_03v3 ad=0 pd=0 as=0 ps=0 w=660 l=56
X559 VDD NAND3_53/a_2506_982# wl[9] VDD pfet_03v3 ad=0 pd=0 as=0 ps=0 w=660 l=56
X560 VDD NAND3_53/a_n593_982# NAND3_53/a_2506_982# VDD pfet_03v3 ad=0 pd=0 as=0 ps=0 w=660 l=56
X561 NAND3_53/a_2506_982# NAND3_53/a_n593_982# VDD VDD pfet_03v3 ad=0 pd=0 as=0 ps=0 w=660 l=56
X562 NAND3_53/a_2506_982# NAND3_53/a_n593_982# VDD VDD pfet_03v3 ad=0 pd=0 as=0 ps=0 w=660 l=56
X563 VDD NAND3_53/a_n593_982# NAND3_53/a_2506_982# VDD pfet_03v3 ad=0 pd=0 as=0 ps=0 w=660 l=56
X564 VDD NAND3_53/a_n593_982# NAND3_53/a_2506_982# VDD pfet_03v3 ad=0 pd=0 as=0 ps=0 w=660 l=56
X565 NAND3_53/m1_n2243_n1314# comp[9] NAND3_53/m1_n3706_n1374# GND nfet_03v3 ad=0.28245u pd=6.192m as=0.28245u ps=6.192m w=508 l=56
X566 NAND3_53/m1_n2243_n1314# comp[9] NAND3_53/m1_n3706_n1374# GND nfet_03v3 ad=0 pd=0 as=0 ps=0 w=508 l=56
X567 NAND3_53/m1_n3706_n1374# comp[9] NAND3_53/m1_n2243_n1314# GND nfet_03v3 ad=0 pd=0 as=0 ps=0 w=508 l=56
X568 NAND3_53/m1_n3706_n1374# comp[9] NAND3_53/m1_n2243_n1314# GND nfet_03v3 ad=0 pd=0 as=0 ps=0 w=508 l=56
X569 GND comp[10] NAND3_53/a_n593_982# GND nfet_03v3 ad=0 pd=0 as=0.10566u ps=2.448m w=508 l=56
X570 GND comp[10] NAND3_53/a_n593_982# GND nfet_03v3 ad=0 pd=0 as=0 ps=0 w=508 l=56
X571 NAND3_53/a_n593_982# comp[10] GND GND nfet_03v3 ad=0 pd=0 as=0 ps=0 w=508 l=56
X572 NAND3_53/a_n593_982# comp[10] GND GND nfet_03v3 ad=0 pd=0 as=0 ps=0 w=508 l=56
X573 GND NAND3_53/a_n593_982# NAND3_53/m1_n2243_n1314# GND nfet_03v3 ad=0 pd=0 as=0 ps=0 w=508 l=56
X574 GND NAND3_53/a_n593_982# NAND3_53/m1_n2243_n1314# GND nfet_03v3 ad=0 pd=0 as=0 ps=0 w=508 l=56
X575 NAND3_53/m1_n2243_n1314# NAND3_53/a_n593_982# GND GND nfet_03v3 ad=0 pd=0 as=0 ps=0 w=508 l=56
X576 NAND3_53/m1_n2243_n1314# NAND3_53/a_n593_982# GND GND nfet_03v3 ad=0 pd=0 as=0 ps=0 w=508 l=56
X577 NAND3_53/m1_n3706_n1374# comp[8] NAND3_53/a_2506_982# GND nfet_03v3 ad=0 pd=0 as=0.10566u ps=2.448m w=508 l=56
X578 NAND3_53/m1_n3706_n1374# comp[8] NAND3_53/a_2506_982# GND nfet_03v3 ad=0 pd=0 as=0 ps=0 w=508 l=56
X579 NAND3_53/a_2506_982# comp[8] NAND3_53/m1_n3706_n1374# GND nfet_03v3 ad=0 pd=0 as=0 ps=0 w=508 l=56
X580 NAND3_53/a_2506_982# comp[8] NAND3_53/m1_n3706_n1374# GND nfet_03v3 ad=0 pd=0 as=0 ps=0 w=508 l=56
X581 GND NAND3_53/a_2506_982# wl[9] GND nfet_03v3 ad=0 pd=0 as=0.10566u ps=2.448m w=508 l=56
X582 GND NAND3_53/a_2506_982# wl[9] GND nfet_03v3 ad=0 pd=0 as=0 ps=0 w=508 l=56
X583 wl[9] NAND3_53/a_2506_982# GND GND nfet_03v3 ad=0 pd=0 as=0 ps=0 w=508 l=56
X584 wl[9] NAND3_53/a_2506_982# GND GND nfet_03v3 ad=0 pd=0 as=0 ps=0 w=508 l=56
X585 VDD GND NAND3_0/a_n593_982# VDD pfet_03v3 ad=0 pd=0 as=0.22308u ps=4.636m w=660 l=56
X586 NAND3_0/a_n593_982# GND VDD VDD pfet_03v3 ad=0 pd=0 as=0 ps=0 w=660 l=56
X587 NAND3_0/a_n593_982# GND VDD VDD pfet_03v3 ad=0 pd=0 as=0 ps=0 w=660 l=56
X588 VDD GND NAND3_0/a_n593_982# VDD pfet_03v3 ad=0 pd=0 as=0 ps=0 w=660 l=56
X589 VDD GND NAND3_0/a_n593_982# VDD pfet_03v3 ad=0 pd=0 as=0 ps=0 w=660 l=56
X590 VDD comp[62] NAND3_0/a_2506_982# VDD pfet_03v3 ad=0 pd=0 as=0.66924u ps=0.01391 w=660 l=56
X591 NAND3_0/a_2506_982# comp[62] VDD VDD pfet_03v3 ad=0 pd=0 as=0 ps=0 w=660 l=56
X592 NAND3_0/a_2506_982# comp[62] VDD VDD pfet_03v3 ad=0 pd=0 as=0 ps=0 w=660 l=56
X593 VDD comp[62] NAND3_0/a_2506_982# VDD pfet_03v3 ad=0 pd=0 as=0 ps=0 w=660 l=56
X594 VDD comp[62] NAND3_0/a_2506_982# VDD pfet_03v3 ad=0 pd=0 as=0 ps=0 w=660 l=56
X595 VDD comp[61] NAND3_0/a_2506_982# VDD pfet_03v3 ad=0 pd=0 as=0 ps=0 w=660 l=56
X596 NAND3_0/a_2506_982# comp[61] VDD VDD pfet_03v3 ad=0 pd=0 as=0 ps=0 w=660 l=56
X597 NAND3_0/a_2506_982# comp[61] VDD VDD pfet_03v3 ad=0 pd=0 as=0 ps=0 w=660 l=56
X598 VDD comp[61] NAND3_0/a_2506_982# VDD pfet_03v3 ad=0 pd=0 as=0 ps=0 w=660 l=56
X599 VDD comp[61] NAND3_0/a_2506_982# VDD pfet_03v3 ad=0 pd=0 as=0 ps=0 w=660 l=56
X600 VDD NAND3_0/a_2506_982# wl[62] VDD pfet_03v3 ad=0 pd=0 as=0.22308u ps=4.636m w=660 l=56
X601 wl[62] NAND3_0/a_2506_982# VDD VDD pfet_03v3 ad=0 pd=0 as=0 ps=0 w=660 l=56
X602 wl[62] NAND3_0/a_2506_982# VDD VDD pfet_03v3 ad=0 pd=0 as=0 ps=0 w=660 l=56
X603 VDD NAND3_0/a_2506_982# wl[62] VDD pfet_03v3 ad=0 pd=0 as=0 ps=0 w=660 l=56
X604 VDD NAND3_0/a_2506_982# wl[62] VDD pfet_03v3 ad=0 pd=0 as=0 ps=0 w=660 l=56
X605 VDD NAND3_0/a_n593_982# NAND3_0/a_2506_982# VDD pfet_03v3 ad=0 pd=0 as=0 ps=0 w=660 l=56
X606 NAND3_0/a_2506_982# NAND3_0/a_n593_982# VDD VDD pfet_03v3 ad=0 pd=0 as=0 ps=0 w=660 l=56
X607 NAND3_0/a_2506_982# NAND3_0/a_n593_982# VDD VDD pfet_03v3 ad=0 pd=0 as=0 ps=0 w=660 l=56
X608 VDD NAND3_0/a_n593_982# NAND3_0/a_2506_982# VDD pfet_03v3 ad=0 pd=0 as=0 ps=0 w=660 l=56
X609 VDD NAND3_0/a_n593_982# NAND3_0/a_2506_982# VDD pfet_03v3 ad=0 pd=0 as=0 ps=0 w=660 l=56
X610 NAND3_0/m1_n2243_n1314# comp[62] NAND3_0/m1_n3706_n1374# GND nfet_03v3 ad=0.28245u pd=6.192m as=0.28245u ps=6.192m w=508 l=56
X611 NAND3_0/m1_n2243_n1314# comp[62] NAND3_0/m1_n3706_n1374# GND nfet_03v3 ad=0 pd=0 as=0 ps=0 w=508 l=56
X612 NAND3_0/m1_n3706_n1374# comp[62] NAND3_0/m1_n2243_n1314# GND nfet_03v3 ad=0 pd=0 as=0 ps=0 w=508 l=56
X613 NAND3_0/m1_n3706_n1374# comp[62] NAND3_0/m1_n2243_n1314# GND nfet_03v3 ad=0 pd=0 as=0 ps=0 w=508 l=56
X614 GND GND NAND3_0/a_n593_982# GND nfet_03v3 ad=0 pd=0 as=0.10566u ps=2.448m w=508 l=56
X615 GND GND NAND3_0/a_n593_982# GND nfet_03v3 ad=0 pd=0 as=0 ps=0 w=508 l=56
X616 NAND3_0/a_n593_982# GND GND GND nfet_03v3 ad=0 pd=0 as=0 ps=0 w=508 l=56
X617 NAND3_0/a_n593_982# GND GND GND nfet_03v3 ad=0 pd=0 as=0 ps=0 w=508 l=56
X618 GND NAND3_0/a_n593_982# NAND3_0/m1_n2243_n1314# GND nfet_03v3 ad=0 pd=0 as=0 ps=0 w=508 l=56
X619 GND NAND3_0/a_n593_982# NAND3_0/m1_n2243_n1314# GND nfet_03v3 ad=0 pd=0 as=0 ps=0 w=508 l=56
X620 NAND3_0/m1_n2243_n1314# NAND3_0/a_n593_982# GND GND nfet_03v3 ad=0 pd=0 as=0 ps=0 w=508 l=56
X621 NAND3_0/m1_n2243_n1314# NAND3_0/a_n593_982# GND GND nfet_03v3 ad=0 pd=0 as=0 ps=0 w=508 l=56
X622 NAND3_0/m1_n3706_n1374# comp[61] NAND3_0/a_2506_982# GND nfet_03v3 ad=0 pd=0 as=0.10566u ps=2.448m w=508 l=56
X623 NAND3_0/m1_n3706_n1374# comp[61] NAND3_0/a_2506_982# GND nfet_03v3 ad=0 pd=0 as=0 ps=0 w=508 l=56
X624 NAND3_0/a_2506_982# comp[61] NAND3_0/m1_n3706_n1374# GND nfet_03v3 ad=0 pd=0 as=0 ps=0 w=508 l=56
X625 NAND3_0/a_2506_982# comp[61] NAND3_0/m1_n3706_n1374# GND nfet_03v3 ad=0 pd=0 as=0 ps=0 w=508 l=56
X626 GND NAND3_0/a_2506_982# wl[62] GND nfet_03v3 ad=0 pd=0 as=0.10566u ps=2.448m w=508 l=56
X627 GND NAND3_0/a_2506_982# wl[62] GND nfet_03v3 ad=0 pd=0 as=0 ps=0 w=508 l=56
X628 wl[62] NAND3_0/a_2506_982# GND GND nfet_03v3 ad=0 pd=0 as=0 ps=0 w=508 l=56
X629 wl[62] NAND3_0/a_2506_982# GND GND nfet_03v3 ad=0 pd=0 as=0 ps=0 w=508 l=56
X630 VDD comp[53] NAND3_10/a_n593_982# VDD pfet_03v3 ad=0 pd=0 as=0.22308u ps=4.636m w=660 l=56
X631 NAND3_10/a_n593_982# comp[53] VDD VDD pfet_03v3 ad=0 pd=0 as=0 ps=0 w=660 l=56
X632 NAND3_10/a_n593_982# comp[53] VDD VDD pfet_03v3 ad=0 pd=0 as=0 ps=0 w=660 l=56
X633 VDD comp[53] NAND3_10/a_n593_982# VDD pfet_03v3 ad=0 pd=0 as=0 ps=0 w=660 l=56
X634 VDD comp[53] NAND3_10/a_n593_982# VDD pfet_03v3 ad=0 pd=0 as=0 ps=0 w=660 l=56
X635 VDD comp[52] NAND3_10/a_2506_982# VDD pfet_03v3 ad=0 pd=0 as=0.66924u ps=0.01391 w=660 l=56
X636 NAND3_10/a_2506_982# comp[52] VDD VDD pfet_03v3 ad=0 pd=0 as=0 ps=0 w=660 l=56
X637 NAND3_10/a_2506_982# comp[52] VDD VDD pfet_03v3 ad=0 pd=0 as=0 ps=0 w=660 l=56
X638 VDD comp[52] NAND3_10/a_2506_982# VDD pfet_03v3 ad=0 pd=0 as=0 ps=0 w=660 l=56
X639 VDD comp[52] NAND3_10/a_2506_982# VDD pfet_03v3 ad=0 pd=0 as=0 ps=0 w=660 l=56
X640 VDD comp[51] NAND3_10/a_2506_982# VDD pfet_03v3 ad=0 pd=0 as=0 ps=0 w=660 l=56
X641 NAND3_10/a_2506_982# comp[51] VDD VDD pfet_03v3 ad=0 pd=0 as=0 ps=0 w=660 l=56
X642 NAND3_10/a_2506_982# comp[51] VDD VDD pfet_03v3 ad=0 pd=0 as=0 ps=0 w=660 l=56
X643 VDD comp[51] NAND3_10/a_2506_982# VDD pfet_03v3 ad=0 pd=0 as=0 ps=0 w=660 l=56
X644 VDD comp[51] NAND3_10/a_2506_982# VDD pfet_03v3 ad=0 pd=0 as=0 ps=0 w=660 l=56
X645 VDD NAND3_10/a_2506_982# wl[52] VDD pfet_03v3 ad=0 pd=0 as=0.22308u ps=4.636m w=660 l=56
X646 wl[52] NAND3_10/a_2506_982# VDD VDD pfet_03v3 ad=0 pd=0 as=0 ps=0 w=660 l=56
X647 wl[52] NAND3_10/a_2506_982# VDD VDD pfet_03v3 ad=0 pd=0 as=0 ps=0 w=660 l=56
X648 VDD NAND3_10/a_2506_982# wl[52] VDD pfet_03v3 ad=0 pd=0 as=0 ps=0 w=660 l=56
X649 VDD NAND3_10/a_2506_982# wl[52] VDD pfet_03v3 ad=0 pd=0 as=0 ps=0 w=660 l=56
X650 VDD NAND3_10/a_n593_982# NAND3_10/a_2506_982# VDD pfet_03v3 ad=0 pd=0 as=0 ps=0 w=660 l=56
X651 NAND3_10/a_2506_982# NAND3_10/a_n593_982# VDD VDD pfet_03v3 ad=0 pd=0 as=0 ps=0 w=660 l=56
X652 NAND3_10/a_2506_982# NAND3_10/a_n593_982# VDD VDD pfet_03v3 ad=0 pd=0 as=0 ps=0 w=660 l=56
X653 VDD NAND3_10/a_n593_982# NAND3_10/a_2506_982# VDD pfet_03v3 ad=0 pd=0 as=0 ps=0 w=660 l=56
X654 VDD NAND3_10/a_n593_982# NAND3_10/a_2506_982# VDD pfet_03v3 ad=0 pd=0 as=0 ps=0 w=660 l=56
X655 NAND3_10/m1_n2243_n1314# comp[52] NAND3_10/m1_n3706_n1374# GND nfet_03v3 ad=0.28245u pd=6.192m as=0.28245u ps=6.192m w=508 l=56
X656 NAND3_10/m1_n2243_n1314# comp[52] NAND3_10/m1_n3706_n1374# GND nfet_03v3 ad=0 pd=0 as=0 ps=0 w=508 l=56
X657 NAND3_10/m1_n3706_n1374# comp[52] NAND3_10/m1_n2243_n1314# GND nfet_03v3 ad=0 pd=0 as=0 ps=0 w=508 l=56
X658 NAND3_10/m1_n3706_n1374# comp[52] NAND3_10/m1_n2243_n1314# GND nfet_03v3 ad=0 pd=0 as=0 ps=0 w=508 l=56
X659 GND comp[53] NAND3_10/a_n593_982# GND nfet_03v3 ad=0 pd=0 as=0.10566u ps=2.448m w=508 l=56
X660 GND comp[53] NAND3_10/a_n593_982# GND nfet_03v3 ad=0 pd=0 as=0 ps=0 w=508 l=56
X661 NAND3_10/a_n593_982# comp[53] GND GND nfet_03v3 ad=0 pd=0 as=0 ps=0 w=508 l=56
X662 NAND3_10/a_n593_982# comp[53] GND GND nfet_03v3 ad=0 pd=0 as=0 ps=0 w=508 l=56
X663 GND NAND3_10/a_n593_982# NAND3_10/m1_n2243_n1314# GND nfet_03v3 ad=0 pd=0 as=0 ps=0 w=508 l=56
X664 GND NAND3_10/a_n593_982# NAND3_10/m1_n2243_n1314# GND nfet_03v3 ad=0 pd=0 as=0 ps=0 w=508 l=56
X665 NAND3_10/m1_n2243_n1314# NAND3_10/a_n593_982# GND GND nfet_03v3 ad=0 pd=0 as=0 ps=0 w=508 l=56
X666 NAND3_10/m1_n2243_n1314# NAND3_10/a_n593_982# GND GND nfet_03v3 ad=0 pd=0 as=0 ps=0 w=508 l=56
X667 NAND3_10/m1_n3706_n1374# comp[51] NAND3_10/a_2506_982# GND nfet_03v3 ad=0 pd=0 as=0.10566u ps=2.448m w=508 l=56
X668 NAND3_10/m1_n3706_n1374# comp[51] NAND3_10/a_2506_982# GND nfet_03v3 ad=0 pd=0 as=0 ps=0 w=508 l=56
X669 NAND3_10/a_2506_982# comp[51] NAND3_10/m1_n3706_n1374# GND nfet_03v3 ad=0 pd=0 as=0 ps=0 w=508 l=56
X670 NAND3_10/a_2506_982# comp[51] NAND3_10/m1_n3706_n1374# GND nfet_03v3 ad=0 pd=0 as=0 ps=0 w=508 l=56
X671 GND NAND3_10/a_2506_982# wl[52] GND nfet_03v3 ad=0 pd=0 as=0.10566u ps=2.448m w=508 l=56
X672 GND NAND3_10/a_2506_982# wl[52] GND nfet_03v3 ad=0 pd=0 as=0 ps=0 w=508 l=56
X673 wl[52] NAND3_10/a_2506_982# GND GND nfet_03v3 ad=0 pd=0 as=0 ps=0 w=508 l=56
X674 wl[52] NAND3_10/a_2506_982# GND GND nfet_03v3 ad=0 pd=0 as=0 ps=0 w=508 l=56
X675 VDD comp[42] NAND3_21/a_n593_982# VDD pfet_03v3 ad=0 pd=0 as=0.22308u ps=4.636m w=660 l=56
X676 NAND3_21/a_n593_982# comp[42] VDD VDD pfet_03v3 ad=0 pd=0 as=0 ps=0 w=660 l=56
X677 NAND3_21/a_n593_982# comp[42] VDD VDD pfet_03v3 ad=0 pd=0 as=0 ps=0 w=660 l=56
X678 VDD comp[42] NAND3_21/a_n593_982# VDD pfet_03v3 ad=0 pd=0 as=0 ps=0 w=660 l=56
X679 VDD comp[42] NAND3_21/a_n593_982# VDD pfet_03v3 ad=0 pd=0 as=0 ps=0 w=660 l=56
X680 VDD comp[41] NAND3_21/a_2506_982# VDD pfet_03v3 ad=0 pd=0 as=0.66924u ps=0.01391 w=660 l=56
X681 NAND3_21/a_2506_982# comp[41] VDD VDD pfet_03v3 ad=0 pd=0 as=0 ps=0 w=660 l=56
X682 NAND3_21/a_2506_982# comp[41] VDD VDD pfet_03v3 ad=0 pd=0 as=0 ps=0 w=660 l=56
X683 VDD comp[41] NAND3_21/a_2506_982# VDD pfet_03v3 ad=0 pd=0 as=0 ps=0 w=660 l=56
X684 VDD comp[41] NAND3_21/a_2506_982# VDD pfet_03v3 ad=0 pd=0 as=0 ps=0 w=660 l=56
X685 VDD comp[40] NAND3_21/a_2506_982# VDD pfet_03v3 ad=0 pd=0 as=0 ps=0 w=660 l=56
X686 NAND3_21/a_2506_982# comp[40] VDD VDD pfet_03v3 ad=0 pd=0 as=0 ps=0 w=660 l=56
X687 NAND3_21/a_2506_982# comp[40] VDD VDD pfet_03v3 ad=0 pd=0 as=0 ps=0 w=660 l=56
X688 VDD comp[40] NAND3_21/a_2506_982# VDD pfet_03v3 ad=0 pd=0 as=0 ps=0 w=660 l=56
X689 VDD comp[40] NAND3_21/a_2506_982# VDD pfet_03v3 ad=0 pd=0 as=0 ps=0 w=660 l=56
X690 VDD NAND3_21/a_2506_982# wl[41] VDD pfet_03v3 ad=0 pd=0 as=0.22308u ps=4.636m w=660 l=56
X691 wl[41] NAND3_21/a_2506_982# VDD VDD pfet_03v3 ad=0 pd=0 as=0 ps=0 w=660 l=56
X692 wl[41] NAND3_21/a_2506_982# VDD VDD pfet_03v3 ad=0 pd=0 as=0 ps=0 w=660 l=56
X693 VDD NAND3_21/a_2506_982# wl[41] VDD pfet_03v3 ad=0 pd=0 as=0 ps=0 w=660 l=56
X694 VDD NAND3_21/a_2506_982# wl[41] VDD pfet_03v3 ad=0 pd=0 as=0 ps=0 w=660 l=56
X695 VDD NAND3_21/a_n593_982# NAND3_21/a_2506_982# VDD pfet_03v3 ad=0 pd=0 as=0 ps=0 w=660 l=56
X696 NAND3_21/a_2506_982# NAND3_21/a_n593_982# VDD VDD pfet_03v3 ad=0 pd=0 as=0 ps=0 w=660 l=56
X697 NAND3_21/a_2506_982# NAND3_21/a_n593_982# VDD VDD pfet_03v3 ad=0 pd=0 as=0 ps=0 w=660 l=56
X698 VDD NAND3_21/a_n593_982# NAND3_21/a_2506_982# VDD pfet_03v3 ad=0 pd=0 as=0 ps=0 w=660 l=56
X699 VDD NAND3_21/a_n593_982# NAND3_21/a_2506_982# VDD pfet_03v3 ad=0 pd=0 as=0 ps=0 w=660 l=56
X700 NAND3_21/m1_n2243_n1314# comp[41] NAND3_21/m1_n3706_n1374# GND nfet_03v3 ad=0.28245u pd=6.192m as=0.28245u ps=6.192m w=508 l=56
X701 NAND3_21/m1_n2243_n1314# comp[41] NAND3_21/m1_n3706_n1374# GND nfet_03v3 ad=0 pd=0 as=0 ps=0 w=508 l=56
X702 NAND3_21/m1_n3706_n1374# comp[41] NAND3_21/m1_n2243_n1314# GND nfet_03v3 ad=0 pd=0 as=0 ps=0 w=508 l=56
X703 NAND3_21/m1_n3706_n1374# comp[41] NAND3_21/m1_n2243_n1314# GND nfet_03v3 ad=0 pd=0 as=0 ps=0 w=508 l=56
X704 GND comp[42] NAND3_21/a_n593_982# GND nfet_03v3 ad=0 pd=0 as=0.10566u ps=2.448m w=508 l=56
X705 GND comp[42] NAND3_21/a_n593_982# GND nfet_03v3 ad=0 pd=0 as=0 ps=0 w=508 l=56
X706 NAND3_21/a_n593_982# comp[42] GND GND nfet_03v3 ad=0 pd=0 as=0 ps=0 w=508 l=56
X707 NAND3_21/a_n593_982# comp[42] GND GND nfet_03v3 ad=0 pd=0 as=0 ps=0 w=508 l=56
X708 GND NAND3_21/a_n593_982# NAND3_21/m1_n2243_n1314# GND nfet_03v3 ad=0 pd=0 as=0 ps=0 w=508 l=56
X709 GND NAND3_21/a_n593_982# NAND3_21/m1_n2243_n1314# GND nfet_03v3 ad=0 pd=0 as=0 ps=0 w=508 l=56
X710 NAND3_21/m1_n2243_n1314# NAND3_21/a_n593_982# GND GND nfet_03v3 ad=0 pd=0 as=0 ps=0 w=508 l=56
X711 NAND3_21/m1_n2243_n1314# NAND3_21/a_n593_982# GND GND nfet_03v3 ad=0 pd=0 as=0 ps=0 w=508 l=56
X712 NAND3_21/m1_n3706_n1374# comp[40] NAND3_21/a_2506_982# GND nfet_03v3 ad=0 pd=0 as=0.10566u ps=2.448m w=508 l=56
X713 NAND3_21/m1_n3706_n1374# comp[40] NAND3_21/a_2506_982# GND nfet_03v3 ad=0 pd=0 as=0 ps=0 w=508 l=56
X714 NAND3_21/a_2506_982# comp[40] NAND3_21/m1_n3706_n1374# GND nfet_03v3 ad=0 pd=0 as=0 ps=0 w=508 l=56
X715 NAND3_21/a_2506_982# comp[40] NAND3_21/m1_n3706_n1374# GND nfet_03v3 ad=0 pd=0 as=0 ps=0 w=508 l=56
X716 GND NAND3_21/a_2506_982# wl[41] GND nfet_03v3 ad=0 pd=0 as=0.10566u ps=2.448m w=508 l=56
X717 GND NAND3_21/a_2506_982# wl[41] GND nfet_03v3 ad=0 pd=0 as=0 ps=0 w=508 l=56
X718 wl[41] NAND3_21/a_2506_982# GND GND nfet_03v3 ad=0 pd=0 as=0 ps=0 w=508 l=56
X719 wl[41] NAND3_21/a_2506_982# GND GND nfet_03v3 ad=0 pd=0 as=0 ps=0 w=508 l=56
X720 VDD comp[31] NAND3_32/a_n593_982# VDD pfet_03v3 ad=0 pd=0 as=0.22308u ps=4.636m w=660 l=56
X721 NAND3_32/a_n593_982# comp[31] VDD VDD pfet_03v3 ad=0 pd=0 as=0 ps=0 w=660 l=56
X722 NAND3_32/a_n593_982# comp[31] VDD VDD pfet_03v3 ad=0 pd=0 as=0 ps=0 w=660 l=56
X723 VDD comp[31] NAND3_32/a_n593_982# VDD pfet_03v3 ad=0 pd=0 as=0 ps=0 w=660 l=56
X724 VDD comp[31] NAND3_32/a_n593_982# VDD pfet_03v3 ad=0 pd=0 as=0 ps=0 w=660 l=56
X725 VDD comp[30] NAND3_32/a_2506_982# VDD pfet_03v3 ad=0 pd=0 as=0.66924u ps=0.01391 w=660 l=56
X726 NAND3_32/a_2506_982# comp[30] VDD VDD pfet_03v3 ad=0 pd=0 as=0 ps=0 w=660 l=56
X727 NAND3_32/a_2506_982# comp[30] VDD VDD pfet_03v3 ad=0 pd=0 as=0 ps=0 w=660 l=56
X728 VDD comp[30] NAND3_32/a_2506_982# VDD pfet_03v3 ad=0 pd=0 as=0 ps=0 w=660 l=56
X729 VDD comp[30] NAND3_32/a_2506_982# VDD pfet_03v3 ad=0 pd=0 as=0 ps=0 w=660 l=56
X730 VDD comp[29] NAND3_32/a_2506_982# VDD pfet_03v3 ad=0 pd=0 as=0 ps=0 w=660 l=56
X731 NAND3_32/a_2506_982# comp[29] VDD VDD pfet_03v3 ad=0 pd=0 as=0 ps=0 w=660 l=56
X732 NAND3_32/a_2506_982# comp[29] VDD VDD pfet_03v3 ad=0 pd=0 as=0 ps=0 w=660 l=56
X733 VDD comp[29] NAND3_32/a_2506_982# VDD pfet_03v3 ad=0 pd=0 as=0 ps=0 w=660 l=56
X734 VDD comp[29] NAND3_32/a_2506_982# VDD pfet_03v3 ad=0 pd=0 as=0 ps=0 w=660 l=56
X735 VDD NAND3_32/a_2506_982# wl[30] VDD pfet_03v3 ad=0 pd=0 as=0.22308u ps=4.636m w=660 l=56
X736 wl[30] NAND3_32/a_2506_982# VDD VDD pfet_03v3 ad=0 pd=0 as=0 ps=0 w=660 l=56
X737 wl[30] NAND3_32/a_2506_982# VDD VDD pfet_03v3 ad=0 pd=0 as=0 ps=0 w=660 l=56
X738 VDD NAND3_32/a_2506_982# wl[30] VDD pfet_03v3 ad=0 pd=0 as=0 ps=0 w=660 l=56
X739 VDD NAND3_32/a_2506_982# wl[30] VDD pfet_03v3 ad=0 pd=0 as=0 ps=0 w=660 l=56
X740 VDD NAND3_32/a_n593_982# NAND3_32/a_2506_982# VDD pfet_03v3 ad=0 pd=0 as=0 ps=0 w=660 l=56
X741 NAND3_32/a_2506_982# NAND3_32/a_n593_982# VDD VDD pfet_03v3 ad=0 pd=0 as=0 ps=0 w=660 l=56
X742 NAND3_32/a_2506_982# NAND3_32/a_n593_982# VDD VDD pfet_03v3 ad=0 pd=0 as=0 ps=0 w=660 l=56
X743 VDD NAND3_32/a_n593_982# NAND3_32/a_2506_982# VDD pfet_03v3 ad=0 pd=0 as=0 ps=0 w=660 l=56
X744 VDD NAND3_32/a_n593_982# NAND3_32/a_2506_982# VDD pfet_03v3 ad=0 pd=0 as=0 ps=0 w=660 l=56
X745 NAND3_32/m1_n2243_n1314# comp[30] NAND3_32/m1_n3706_n1374# GND nfet_03v3 ad=0.28245u pd=6.192m as=0.28245u ps=6.192m w=508 l=56
X746 NAND3_32/m1_n2243_n1314# comp[30] NAND3_32/m1_n3706_n1374# GND nfet_03v3 ad=0 pd=0 as=0 ps=0 w=508 l=56
X747 NAND3_32/m1_n3706_n1374# comp[30] NAND3_32/m1_n2243_n1314# GND nfet_03v3 ad=0 pd=0 as=0 ps=0 w=508 l=56
X748 NAND3_32/m1_n3706_n1374# comp[30] NAND3_32/m1_n2243_n1314# GND nfet_03v3 ad=0 pd=0 as=0 ps=0 w=508 l=56
X749 GND comp[31] NAND3_32/a_n593_982# GND nfet_03v3 ad=0 pd=0 as=0.10566u ps=2.448m w=508 l=56
X750 GND comp[31] NAND3_32/a_n593_982# GND nfet_03v3 ad=0 pd=0 as=0 ps=0 w=508 l=56
X751 NAND3_32/a_n593_982# comp[31] GND GND nfet_03v3 ad=0 pd=0 as=0 ps=0 w=508 l=56
X752 NAND3_32/a_n593_982# comp[31] GND GND nfet_03v3 ad=0 pd=0 as=0 ps=0 w=508 l=56
X753 GND NAND3_32/a_n593_982# NAND3_32/m1_n2243_n1314# GND nfet_03v3 ad=0 pd=0 as=0 ps=0 w=508 l=56
X754 GND NAND3_32/a_n593_982# NAND3_32/m1_n2243_n1314# GND nfet_03v3 ad=0 pd=0 as=0 ps=0 w=508 l=56
X755 NAND3_32/m1_n2243_n1314# NAND3_32/a_n593_982# GND GND nfet_03v3 ad=0 pd=0 as=0 ps=0 w=508 l=56
X756 NAND3_32/m1_n2243_n1314# NAND3_32/a_n593_982# GND GND nfet_03v3 ad=0 pd=0 as=0 ps=0 w=508 l=56
X757 NAND3_32/m1_n3706_n1374# comp[29] NAND3_32/a_2506_982# GND nfet_03v3 ad=0 pd=0 as=0.10566u ps=2.448m w=508 l=56
X758 NAND3_32/m1_n3706_n1374# comp[29] NAND3_32/a_2506_982# GND nfet_03v3 ad=0 pd=0 as=0 ps=0 w=508 l=56
X759 NAND3_32/a_2506_982# comp[29] NAND3_32/m1_n3706_n1374# GND nfet_03v3 ad=0 pd=0 as=0 ps=0 w=508 l=56
X760 NAND3_32/a_2506_982# comp[29] NAND3_32/m1_n3706_n1374# GND nfet_03v3 ad=0 pd=0 as=0 ps=0 w=508 l=56
X761 GND NAND3_32/a_2506_982# wl[30] GND nfet_03v3 ad=0 pd=0 as=0.10566u ps=2.448m w=508 l=56
X762 GND NAND3_32/a_2506_982# wl[30] GND nfet_03v3 ad=0 pd=0 as=0 ps=0 w=508 l=56
X763 wl[30] NAND3_32/a_2506_982# GND GND nfet_03v3 ad=0 pd=0 as=0 ps=0 w=508 l=56
X764 wl[30] NAND3_32/a_2506_982# GND GND nfet_03v3 ad=0 pd=0 as=0 ps=0 w=508 l=56
X765 VDD comp[20] NAND3_43/a_n593_982# VDD pfet_03v3 ad=0 pd=0 as=0.22308u ps=4.636m w=660 l=56
X766 NAND3_43/a_n593_982# comp[20] VDD VDD pfet_03v3 ad=0 pd=0 as=0 ps=0 w=660 l=56
X767 NAND3_43/a_n593_982# comp[20] VDD VDD pfet_03v3 ad=0 pd=0 as=0 ps=0 w=660 l=56
X768 VDD comp[20] NAND3_43/a_n593_982# VDD pfet_03v3 ad=0 pd=0 as=0 ps=0 w=660 l=56
X769 VDD comp[20] NAND3_43/a_n593_982# VDD pfet_03v3 ad=0 pd=0 as=0 ps=0 w=660 l=56
X770 VDD comp[19] NAND3_43/a_2506_982# VDD pfet_03v3 ad=0 pd=0 as=0.66924u ps=0.01391 w=660 l=56
X771 NAND3_43/a_2506_982# comp[19] VDD VDD pfet_03v3 ad=0 pd=0 as=0 ps=0 w=660 l=56
X772 NAND3_43/a_2506_982# comp[19] VDD VDD pfet_03v3 ad=0 pd=0 as=0 ps=0 w=660 l=56
X773 VDD comp[19] NAND3_43/a_2506_982# VDD pfet_03v3 ad=0 pd=0 as=0 ps=0 w=660 l=56
X774 VDD comp[19] NAND3_43/a_2506_982# VDD pfet_03v3 ad=0 pd=0 as=0 ps=0 w=660 l=56
X775 VDD comp[18] NAND3_43/a_2506_982# VDD pfet_03v3 ad=0 pd=0 as=0 ps=0 w=660 l=56
X776 NAND3_43/a_2506_982# comp[18] VDD VDD pfet_03v3 ad=0 pd=0 as=0 ps=0 w=660 l=56
X777 NAND3_43/a_2506_982# comp[18] VDD VDD pfet_03v3 ad=0 pd=0 as=0 ps=0 w=660 l=56
X778 VDD comp[18] NAND3_43/a_2506_982# VDD pfet_03v3 ad=0 pd=0 as=0 ps=0 w=660 l=56
X779 VDD comp[18] NAND3_43/a_2506_982# VDD pfet_03v3 ad=0 pd=0 as=0 ps=0 w=660 l=56
X780 VDD NAND3_43/a_2506_982# wl[19] VDD pfet_03v3 ad=0 pd=0 as=0.22308u ps=4.636m w=660 l=56
X781 wl[19] NAND3_43/a_2506_982# VDD VDD pfet_03v3 ad=0 pd=0 as=0 ps=0 w=660 l=56
X782 wl[19] NAND3_43/a_2506_982# VDD VDD pfet_03v3 ad=0 pd=0 as=0 ps=0 w=660 l=56
X783 VDD NAND3_43/a_2506_982# wl[19] VDD pfet_03v3 ad=0 pd=0 as=0 ps=0 w=660 l=56
X784 VDD NAND3_43/a_2506_982# wl[19] VDD pfet_03v3 ad=0 pd=0 as=0 ps=0 w=660 l=56
X785 VDD NAND3_43/a_n593_982# NAND3_43/a_2506_982# VDD pfet_03v3 ad=0 pd=0 as=0 ps=0 w=660 l=56
X786 NAND3_43/a_2506_982# NAND3_43/a_n593_982# VDD VDD pfet_03v3 ad=0 pd=0 as=0 ps=0 w=660 l=56
X787 NAND3_43/a_2506_982# NAND3_43/a_n593_982# VDD VDD pfet_03v3 ad=0 pd=0 as=0 ps=0 w=660 l=56
X788 VDD NAND3_43/a_n593_982# NAND3_43/a_2506_982# VDD pfet_03v3 ad=0 pd=0 as=0 ps=0 w=660 l=56
X789 VDD NAND3_43/a_n593_982# NAND3_43/a_2506_982# VDD pfet_03v3 ad=0 pd=0 as=0 ps=0 w=660 l=56
X790 NAND3_43/m1_n2243_n1314# comp[19] NAND3_43/m1_n3706_n1374# GND nfet_03v3 ad=0.28245u pd=6.192m as=0.28245u ps=6.192m w=508 l=56
X791 NAND3_43/m1_n2243_n1314# comp[19] NAND3_43/m1_n3706_n1374# GND nfet_03v3 ad=0 pd=0 as=0 ps=0 w=508 l=56
X792 NAND3_43/m1_n3706_n1374# comp[19] NAND3_43/m1_n2243_n1314# GND nfet_03v3 ad=0 pd=0 as=0 ps=0 w=508 l=56
X793 NAND3_43/m1_n3706_n1374# comp[19] NAND3_43/m1_n2243_n1314# GND nfet_03v3 ad=0 pd=0 as=0 ps=0 w=508 l=56
X794 GND comp[20] NAND3_43/a_n593_982# GND nfet_03v3 ad=0 pd=0 as=0.10566u ps=2.448m w=508 l=56
X795 GND comp[20] NAND3_43/a_n593_982# GND nfet_03v3 ad=0 pd=0 as=0 ps=0 w=508 l=56
X796 NAND3_43/a_n593_982# comp[20] GND GND nfet_03v3 ad=0 pd=0 as=0 ps=0 w=508 l=56
X797 NAND3_43/a_n593_982# comp[20] GND GND nfet_03v3 ad=0 pd=0 as=0 ps=0 w=508 l=56
X798 GND NAND3_43/a_n593_982# NAND3_43/m1_n2243_n1314# GND nfet_03v3 ad=0 pd=0 as=0 ps=0 w=508 l=56
X799 GND NAND3_43/a_n593_982# NAND3_43/m1_n2243_n1314# GND nfet_03v3 ad=0 pd=0 as=0 ps=0 w=508 l=56
X800 NAND3_43/m1_n2243_n1314# NAND3_43/a_n593_982# GND GND nfet_03v3 ad=0 pd=0 as=0 ps=0 w=508 l=56
X801 NAND3_43/m1_n2243_n1314# NAND3_43/a_n593_982# GND GND nfet_03v3 ad=0 pd=0 as=0 ps=0 w=508 l=56
X802 NAND3_43/m1_n3706_n1374# comp[18] NAND3_43/a_2506_982# GND nfet_03v3 ad=0 pd=0 as=0.10566u ps=2.448m w=508 l=56
X803 NAND3_43/m1_n3706_n1374# comp[18] NAND3_43/a_2506_982# GND nfet_03v3 ad=0 pd=0 as=0 ps=0 w=508 l=56
X804 NAND3_43/a_2506_982# comp[18] NAND3_43/m1_n3706_n1374# GND nfet_03v3 ad=0 pd=0 as=0 ps=0 w=508 l=56
X805 NAND3_43/a_2506_982# comp[18] NAND3_43/m1_n3706_n1374# GND nfet_03v3 ad=0 pd=0 as=0 ps=0 w=508 l=56
X806 GND NAND3_43/a_2506_982# wl[19] GND nfet_03v3 ad=0 pd=0 as=0.10566u ps=2.448m w=508 l=56
X807 GND NAND3_43/a_2506_982# wl[19] GND nfet_03v3 ad=0 pd=0 as=0 ps=0 w=508 l=56
X808 wl[19] NAND3_43/a_2506_982# GND GND nfet_03v3 ad=0 pd=0 as=0 ps=0 w=508 l=56
X809 wl[19] NAND3_43/a_2506_982# GND GND nfet_03v3 ad=0 pd=0 as=0 ps=0 w=508 l=56
X810 VDD comp[9] NAND3_54/a_n593_982# VDD pfet_03v3 ad=0 pd=0 as=0.22308u ps=4.636m w=660 l=56
X811 NAND3_54/a_n593_982# comp[9] VDD VDD pfet_03v3 ad=0 pd=0 as=0 ps=0 w=660 l=56
X812 NAND3_54/a_n593_982# comp[9] VDD VDD pfet_03v3 ad=0 pd=0 as=0 ps=0 w=660 l=56
X813 VDD comp[9] NAND3_54/a_n593_982# VDD pfet_03v3 ad=0 pd=0 as=0 ps=0 w=660 l=56
X814 VDD comp[9] NAND3_54/a_n593_982# VDD pfet_03v3 ad=0 pd=0 as=0 ps=0 w=660 l=56
X815 VDD comp[8] NAND3_54/a_2506_982# VDD pfet_03v3 ad=0 pd=0 as=0.66924u ps=0.01391 w=660 l=56
X816 NAND3_54/a_2506_982# comp[8] VDD VDD pfet_03v3 ad=0 pd=0 as=0 ps=0 w=660 l=56
X817 NAND3_54/a_2506_982# comp[8] VDD VDD pfet_03v3 ad=0 pd=0 as=0 ps=0 w=660 l=56
X818 VDD comp[8] NAND3_54/a_2506_982# VDD pfet_03v3 ad=0 pd=0 as=0 ps=0 w=660 l=56
X819 VDD comp[8] NAND3_54/a_2506_982# VDD pfet_03v3 ad=0 pd=0 as=0 ps=0 w=660 l=56
X820 VDD comp[7] NAND3_54/a_2506_982# VDD pfet_03v3 ad=0 pd=0 as=0 ps=0 w=660 l=56
X821 NAND3_54/a_2506_982# comp[7] VDD VDD pfet_03v3 ad=0 pd=0 as=0 ps=0 w=660 l=56
X822 NAND3_54/a_2506_982# comp[7] VDD VDD pfet_03v3 ad=0 pd=0 as=0 ps=0 w=660 l=56
X823 VDD comp[7] NAND3_54/a_2506_982# VDD pfet_03v3 ad=0 pd=0 as=0 ps=0 w=660 l=56
X824 VDD comp[7] NAND3_54/a_2506_982# VDD pfet_03v3 ad=0 pd=0 as=0 ps=0 w=660 l=56
X825 VDD NAND3_54/a_2506_982# wl[8] VDD pfet_03v3 ad=0 pd=0 as=0.22308u ps=4.636m w=660 l=56
X826 wl[8] NAND3_54/a_2506_982# VDD VDD pfet_03v3 ad=0 pd=0 as=0 ps=0 w=660 l=56
X827 wl[8] NAND3_54/a_2506_982# VDD VDD pfet_03v3 ad=0 pd=0 as=0 ps=0 w=660 l=56
X828 VDD NAND3_54/a_2506_982# wl[8] VDD pfet_03v3 ad=0 pd=0 as=0 ps=0 w=660 l=56
X829 VDD NAND3_54/a_2506_982# wl[8] VDD pfet_03v3 ad=0 pd=0 as=0 ps=0 w=660 l=56
X830 VDD NAND3_54/a_n593_982# NAND3_54/a_2506_982# VDD pfet_03v3 ad=0 pd=0 as=0 ps=0 w=660 l=56
X831 NAND3_54/a_2506_982# NAND3_54/a_n593_982# VDD VDD pfet_03v3 ad=0 pd=0 as=0 ps=0 w=660 l=56
X832 NAND3_54/a_2506_982# NAND3_54/a_n593_982# VDD VDD pfet_03v3 ad=0 pd=0 as=0 ps=0 w=660 l=56
X833 VDD NAND3_54/a_n593_982# NAND3_54/a_2506_982# VDD pfet_03v3 ad=0 pd=0 as=0 ps=0 w=660 l=56
X834 VDD NAND3_54/a_n593_982# NAND3_54/a_2506_982# VDD pfet_03v3 ad=0 pd=0 as=0 ps=0 w=660 l=56
X835 NAND3_54/m1_n2243_n1314# comp[8] NAND3_54/m1_n3706_n1374# GND nfet_03v3 ad=0.28245u pd=6.192m as=0.28245u ps=6.192m w=508 l=56
X836 NAND3_54/m1_n2243_n1314# comp[8] NAND3_54/m1_n3706_n1374# GND nfet_03v3 ad=0 pd=0 as=0 ps=0 w=508 l=56
X837 NAND3_54/m1_n3706_n1374# comp[8] NAND3_54/m1_n2243_n1314# GND nfet_03v3 ad=0 pd=0 as=0 ps=0 w=508 l=56
X838 NAND3_54/m1_n3706_n1374# comp[8] NAND3_54/m1_n2243_n1314# GND nfet_03v3 ad=0 pd=0 as=0 ps=0 w=508 l=56
X839 GND comp[9] NAND3_54/a_n593_982# GND nfet_03v3 ad=0 pd=0 as=0.10566u ps=2.448m w=508 l=56
X840 GND comp[9] NAND3_54/a_n593_982# GND nfet_03v3 ad=0 pd=0 as=0 ps=0 w=508 l=56
X841 NAND3_54/a_n593_982# comp[9] GND GND nfet_03v3 ad=0 pd=0 as=0 ps=0 w=508 l=56
X842 NAND3_54/a_n593_982# comp[9] GND GND nfet_03v3 ad=0 pd=0 as=0 ps=0 w=508 l=56
X843 GND NAND3_54/a_n593_982# NAND3_54/m1_n2243_n1314# GND nfet_03v3 ad=0 pd=0 as=0 ps=0 w=508 l=56
X844 GND NAND3_54/a_n593_982# NAND3_54/m1_n2243_n1314# GND nfet_03v3 ad=0 pd=0 as=0 ps=0 w=508 l=56
X845 NAND3_54/m1_n2243_n1314# NAND3_54/a_n593_982# GND GND nfet_03v3 ad=0 pd=0 as=0 ps=0 w=508 l=56
X846 NAND3_54/m1_n2243_n1314# NAND3_54/a_n593_982# GND GND nfet_03v3 ad=0 pd=0 as=0 ps=0 w=508 l=56
X847 NAND3_54/m1_n3706_n1374# comp[7] NAND3_54/a_2506_982# GND nfet_03v3 ad=0 pd=0 as=0.10566u ps=2.448m w=508 l=56
X848 NAND3_54/m1_n3706_n1374# comp[7] NAND3_54/a_2506_982# GND nfet_03v3 ad=0 pd=0 as=0 ps=0 w=508 l=56
X849 NAND3_54/a_2506_982# comp[7] NAND3_54/m1_n3706_n1374# GND nfet_03v3 ad=0 pd=0 as=0 ps=0 w=508 l=56
X850 NAND3_54/a_2506_982# comp[7] NAND3_54/m1_n3706_n1374# GND nfet_03v3 ad=0 pd=0 as=0 ps=0 w=508 l=56
X851 GND NAND3_54/a_2506_982# wl[8] GND nfet_03v3 ad=0 pd=0 as=0.10566u ps=2.448m w=508 l=56
X852 GND NAND3_54/a_2506_982# wl[8] GND nfet_03v3 ad=0 pd=0 as=0 ps=0 w=508 l=56
X853 wl[8] NAND3_54/a_2506_982# GND GND nfet_03v3 ad=0 pd=0 as=0 ps=0 w=508 l=56
X854 wl[8] NAND3_54/a_2506_982# GND GND nfet_03v3 ad=0 pd=0 as=0 ps=0 w=508 l=56
X855 VDD comp[62] NAND3_1/a_n593_982# VDD pfet_03v3 ad=0 pd=0 as=0.22308u ps=4.636m w=660 l=56
X856 NAND3_1/a_n593_982# comp[62] VDD VDD pfet_03v3 ad=0 pd=0 as=0 ps=0 w=660 l=56
X857 NAND3_1/a_n593_982# comp[62] VDD VDD pfet_03v3 ad=0 pd=0 as=0 ps=0 w=660 l=56
X858 VDD comp[62] NAND3_1/a_n593_982# VDD pfet_03v3 ad=0 pd=0 as=0 ps=0 w=660 l=56
X859 VDD comp[62] NAND3_1/a_n593_982# VDD pfet_03v3 ad=0 pd=0 as=0 ps=0 w=660 l=56
X860 VDD comp[61] NAND3_1/a_2506_982# VDD pfet_03v3 ad=0 pd=0 as=0.66924u ps=0.01391 w=660 l=56
X861 NAND3_1/a_2506_982# comp[61] VDD VDD pfet_03v3 ad=0 pd=0 as=0 ps=0 w=660 l=56
X862 NAND3_1/a_2506_982# comp[61] VDD VDD pfet_03v3 ad=0 pd=0 as=0 ps=0 w=660 l=56
X863 VDD comp[61] NAND3_1/a_2506_982# VDD pfet_03v3 ad=0 pd=0 as=0 ps=0 w=660 l=56
X864 VDD comp[61] NAND3_1/a_2506_982# VDD pfet_03v3 ad=0 pd=0 as=0 ps=0 w=660 l=56
X865 VDD comp[60] NAND3_1/a_2506_982# VDD pfet_03v3 ad=0 pd=0 as=0 ps=0 w=660 l=56
X866 NAND3_1/a_2506_982# comp[60] VDD VDD pfet_03v3 ad=0 pd=0 as=0 ps=0 w=660 l=56
X867 NAND3_1/a_2506_982# comp[60] VDD VDD pfet_03v3 ad=0 pd=0 as=0 ps=0 w=660 l=56
X868 VDD comp[60] NAND3_1/a_2506_982# VDD pfet_03v3 ad=0 pd=0 as=0 ps=0 w=660 l=56
X869 VDD comp[60] NAND3_1/a_2506_982# VDD pfet_03v3 ad=0 pd=0 as=0 ps=0 w=660 l=56
X870 VDD NAND3_1/a_2506_982# wl[61] VDD pfet_03v3 ad=0 pd=0 as=0.22308u ps=4.636m w=660 l=56
X871 wl[61] NAND3_1/a_2506_982# VDD VDD pfet_03v3 ad=0 pd=0 as=0 ps=0 w=660 l=56
X872 wl[61] NAND3_1/a_2506_982# VDD VDD pfet_03v3 ad=0 pd=0 as=0 ps=0 w=660 l=56
X873 VDD NAND3_1/a_2506_982# wl[61] VDD pfet_03v3 ad=0 pd=0 as=0 ps=0 w=660 l=56
X874 VDD NAND3_1/a_2506_982# wl[61] VDD pfet_03v3 ad=0 pd=0 as=0 ps=0 w=660 l=56
X875 VDD NAND3_1/a_n593_982# NAND3_1/a_2506_982# VDD pfet_03v3 ad=0 pd=0 as=0 ps=0 w=660 l=56
X876 NAND3_1/a_2506_982# NAND3_1/a_n593_982# VDD VDD pfet_03v3 ad=0 pd=0 as=0 ps=0 w=660 l=56
X877 NAND3_1/a_2506_982# NAND3_1/a_n593_982# VDD VDD pfet_03v3 ad=0 pd=0 as=0 ps=0 w=660 l=56
X878 VDD NAND3_1/a_n593_982# NAND3_1/a_2506_982# VDD pfet_03v3 ad=0 pd=0 as=0 ps=0 w=660 l=56
X879 VDD NAND3_1/a_n593_982# NAND3_1/a_2506_982# VDD pfet_03v3 ad=0 pd=0 as=0 ps=0 w=660 l=56
X880 NAND3_1/m1_n2243_n1314# comp[61] NAND3_1/m1_n3706_n1374# GND nfet_03v3 ad=0.28245u pd=6.192m as=0.28245u ps=6.192m w=508 l=56
X881 NAND3_1/m1_n2243_n1314# comp[61] NAND3_1/m1_n3706_n1374# GND nfet_03v3 ad=0 pd=0 as=0 ps=0 w=508 l=56
X882 NAND3_1/m1_n3706_n1374# comp[61] NAND3_1/m1_n2243_n1314# GND nfet_03v3 ad=0 pd=0 as=0 ps=0 w=508 l=56
X883 NAND3_1/m1_n3706_n1374# comp[61] NAND3_1/m1_n2243_n1314# GND nfet_03v3 ad=0 pd=0 as=0 ps=0 w=508 l=56
X884 GND comp[62] NAND3_1/a_n593_982# GND nfet_03v3 ad=0 pd=0 as=0.10566u ps=2.448m w=508 l=56
X885 GND comp[62] NAND3_1/a_n593_982# GND nfet_03v3 ad=0 pd=0 as=0 ps=0 w=508 l=56
X886 NAND3_1/a_n593_982# comp[62] GND GND nfet_03v3 ad=0 pd=0 as=0 ps=0 w=508 l=56
X887 NAND3_1/a_n593_982# comp[62] GND GND nfet_03v3 ad=0 pd=0 as=0 ps=0 w=508 l=56
X888 GND NAND3_1/a_n593_982# NAND3_1/m1_n2243_n1314# GND nfet_03v3 ad=0 pd=0 as=0 ps=0 w=508 l=56
X889 GND NAND3_1/a_n593_982# NAND3_1/m1_n2243_n1314# GND nfet_03v3 ad=0 pd=0 as=0 ps=0 w=508 l=56
X890 NAND3_1/m1_n2243_n1314# NAND3_1/a_n593_982# GND GND nfet_03v3 ad=0 pd=0 as=0 ps=0 w=508 l=56
X891 NAND3_1/m1_n2243_n1314# NAND3_1/a_n593_982# GND GND nfet_03v3 ad=0 pd=0 as=0 ps=0 w=508 l=56
X892 NAND3_1/m1_n3706_n1374# comp[60] NAND3_1/a_2506_982# GND nfet_03v3 ad=0 pd=0 as=0.10566u ps=2.448m w=508 l=56
X893 NAND3_1/m1_n3706_n1374# comp[60] NAND3_1/a_2506_982# GND nfet_03v3 ad=0 pd=0 as=0 ps=0 w=508 l=56
X894 NAND3_1/a_2506_982# comp[60] NAND3_1/m1_n3706_n1374# GND nfet_03v3 ad=0 pd=0 as=0 ps=0 w=508 l=56
X895 NAND3_1/a_2506_982# comp[60] NAND3_1/m1_n3706_n1374# GND nfet_03v3 ad=0 pd=0 as=0 ps=0 w=508 l=56
X896 GND NAND3_1/a_2506_982# wl[61] GND nfet_03v3 ad=0 pd=0 as=0.10566u ps=2.448m w=508 l=56
X897 GND NAND3_1/a_2506_982# wl[61] GND nfet_03v3 ad=0 pd=0 as=0 ps=0 w=508 l=56
X898 wl[61] NAND3_1/a_2506_982# GND GND nfet_03v3 ad=0 pd=0 as=0 ps=0 w=508 l=56
X899 wl[61] NAND3_1/a_2506_982# GND GND nfet_03v3 ad=0 pd=0 as=0 ps=0 w=508 l=56
X900 VDD comp[52] NAND3_11/a_n593_982# VDD pfet_03v3 ad=0 pd=0 as=0.22308u ps=4.636m w=660 l=56
X901 NAND3_11/a_n593_982# comp[52] VDD VDD pfet_03v3 ad=0 pd=0 as=0 ps=0 w=660 l=56
X902 NAND3_11/a_n593_982# comp[52] VDD VDD pfet_03v3 ad=0 pd=0 as=0 ps=0 w=660 l=56
X903 VDD comp[52] NAND3_11/a_n593_982# VDD pfet_03v3 ad=0 pd=0 as=0 ps=0 w=660 l=56
X904 VDD comp[52] NAND3_11/a_n593_982# VDD pfet_03v3 ad=0 pd=0 as=0 ps=0 w=660 l=56
X905 VDD comp[51] NAND3_11/a_2506_982# VDD pfet_03v3 ad=0 pd=0 as=0.66924u ps=0.01391 w=660 l=56
X906 NAND3_11/a_2506_982# comp[51] VDD VDD pfet_03v3 ad=0 pd=0 as=0 ps=0 w=660 l=56
X907 NAND3_11/a_2506_982# comp[51] VDD VDD pfet_03v3 ad=0 pd=0 as=0 ps=0 w=660 l=56
X908 VDD comp[51] NAND3_11/a_2506_982# VDD pfet_03v3 ad=0 pd=0 as=0 ps=0 w=660 l=56
X909 VDD comp[51] NAND3_11/a_2506_982# VDD pfet_03v3 ad=0 pd=0 as=0 ps=0 w=660 l=56
X910 VDD comp[50] NAND3_11/a_2506_982# VDD pfet_03v3 ad=0 pd=0 as=0 ps=0 w=660 l=56
X911 NAND3_11/a_2506_982# comp[50] VDD VDD pfet_03v3 ad=0 pd=0 as=0 ps=0 w=660 l=56
X912 NAND3_11/a_2506_982# comp[50] VDD VDD pfet_03v3 ad=0 pd=0 as=0 ps=0 w=660 l=56
X913 VDD comp[50] NAND3_11/a_2506_982# VDD pfet_03v3 ad=0 pd=0 as=0 ps=0 w=660 l=56
X914 VDD comp[50] NAND3_11/a_2506_982# VDD pfet_03v3 ad=0 pd=0 as=0 ps=0 w=660 l=56
X915 VDD NAND3_11/a_2506_982# wl[51] VDD pfet_03v3 ad=0 pd=0 as=0.22308u ps=4.636m w=660 l=56
X916 wl[51] NAND3_11/a_2506_982# VDD VDD pfet_03v3 ad=0 pd=0 as=0 ps=0 w=660 l=56
X917 wl[51] NAND3_11/a_2506_982# VDD VDD pfet_03v3 ad=0 pd=0 as=0 ps=0 w=660 l=56
X918 VDD NAND3_11/a_2506_982# wl[51] VDD pfet_03v3 ad=0 pd=0 as=0 ps=0 w=660 l=56
X919 VDD NAND3_11/a_2506_982# wl[51] VDD pfet_03v3 ad=0 pd=0 as=0 ps=0 w=660 l=56
X920 VDD NAND3_11/a_n593_982# NAND3_11/a_2506_982# VDD pfet_03v3 ad=0 pd=0 as=0 ps=0 w=660 l=56
X921 NAND3_11/a_2506_982# NAND3_11/a_n593_982# VDD VDD pfet_03v3 ad=0 pd=0 as=0 ps=0 w=660 l=56
X922 NAND3_11/a_2506_982# NAND3_11/a_n593_982# VDD VDD pfet_03v3 ad=0 pd=0 as=0 ps=0 w=660 l=56
X923 VDD NAND3_11/a_n593_982# NAND3_11/a_2506_982# VDD pfet_03v3 ad=0 pd=0 as=0 ps=0 w=660 l=56
X924 VDD NAND3_11/a_n593_982# NAND3_11/a_2506_982# VDD pfet_03v3 ad=0 pd=0 as=0 ps=0 w=660 l=56
X925 NAND3_11/m1_n2243_n1314# comp[51] NAND3_11/m1_n3706_n1374# GND nfet_03v3 ad=0.28245u pd=6.192m as=0.28245u ps=6.192m w=508 l=56
X926 NAND3_11/m1_n2243_n1314# comp[51] NAND3_11/m1_n3706_n1374# GND nfet_03v3 ad=0 pd=0 as=0 ps=0 w=508 l=56
X927 NAND3_11/m1_n3706_n1374# comp[51] NAND3_11/m1_n2243_n1314# GND nfet_03v3 ad=0 pd=0 as=0 ps=0 w=508 l=56
X928 NAND3_11/m1_n3706_n1374# comp[51] NAND3_11/m1_n2243_n1314# GND nfet_03v3 ad=0 pd=0 as=0 ps=0 w=508 l=56
X929 GND comp[52] NAND3_11/a_n593_982# GND nfet_03v3 ad=0 pd=0 as=0.10566u ps=2.448m w=508 l=56
X930 GND comp[52] NAND3_11/a_n593_982# GND nfet_03v3 ad=0 pd=0 as=0 ps=0 w=508 l=56
X931 NAND3_11/a_n593_982# comp[52] GND GND nfet_03v3 ad=0 pd=0 as=0 ps=0 w=508 l=56
X932 NAND3_11/a_n593_982# comp[52] GND GND nfet_03v3 ad=0 pd=0 as=0 ps=0 w=508 l=56
X933 GND NAND3_11/a_n593_982# NAND3_11/m1_n2243_n1314# GND nfet_03v3 ad=0 pd=0 as=0 ps=0 w=508 l=56
X934 GND NAND3_11/a_n593_982# NAND3_11/m1_n2243_n1314# GND nfet_03v3 ad=0 pd=0 as=0 ps=0 w=508 l=56
X935 NAND3_11/m1_n2243_n1314# NAND3_11/a_n593_982# GND GND nfet_03v3 ad=0 pd=0 as=0 ps=0 w=508 l=56
X936 NAND3_11/m1_n2243_n1314# NAND3_11/a_n593_982# GND GND nfet_03v3 ad=0 pd=0 as=0 ps=0 w=508 l=56
X937 NAND3_11/m1_n3706_n1374# comp[50] NAND3_11/a_2506_982# GND nfet_03v3 ad=0 pd=0 as=0.10566u ps=2.448m w=508 l=56
X938 NAND3_11/m1_n3706_n1374# comp[50] NAND3_11/a_2506_982# GND nfet_03v3 ad=0 pd=0 as=0 ps=0 w=508 l=56
X939 NAND3_11/a_2506_982# comp[50] NAND3_11/m1_n3706_n1374# GND nfet_03v3 ad=0 pd=0 as=0 ps=0 w=508 l=56
X940 NAND3_11/a_2506_982# comp[50] NAND3_11/m1_n3706_n1374# GND nfet_03v3 ad=0 pd=0 as=0 ps=0 w=508 l=56
X941 GND NAND3_11/a_2506_982# wl[51] GND nfet_03v3 ad=0 pd=0 as=0.10566u ps=2.448m w=508 l=56
X942 GND NAND3_11/a_2506_982# wl[51] GND nfet_03v3 ad=0 pd=0 as=0 ps=0 w=508 l=56
X943 wl[51] NAND3_11/a_2506_982# GND GND nfet_03v3 ad=0 pd=0 as=0 ps=0 w=508 l=56
X944 wl[51] NAND3_11/a_2506_982# GND GND nfet_03v3 ad=0 pd=0 as=0 ps=0 w=508 l=56
X945 VDD comp[41] NAND3_22/a_n593_982# VDD pfet_03v3 ad=0 pd=0 as=0.22308u ps=4.636m w=660 l=56
X946 NAND3_22/a_n593_982# comp[41] VDD VDD pfet_03v3 ad=0 pd=0 as=0 ps=0 w=660 l=56
X947 NAND3_22/a_n593_982# comp[41] VDD VDD pfet_03v3 ad=0 pd=0 as=0 ps=0 w=660 l=56
X948 VDD comp[41] NAND3_22/a_n593_982# VDD pfet_03v3 ad=0 pd=0 as=0 ps=0 w=660 l=56
X949 VDD comp[41] NAND3_22/a_n593_982# VDD pfet_03v3 ad=0 pd=0 as=0 ps=0 w=660 l=56
X950 VDD comp[40] NAND3_22/a_2506_982# VDD pfet_03v3 ad=0 pd=0 as=0.66924u ps=0.01391 w=660 l=56
X951 NAND3_22/a_2506_982# comp[40] VDD VDD pfet_03v3 ad=0 pd=0 as=0 ps=0 w=660 l=56
X952 NAND3_22/a_2506_982# comp[40] VDD VDD pfet_03v3 ad=0 pd=0 as=0 ps=0 w=660 l=56
X953 VDD comp[40] NAND3_22/a_2506_982# VDD pfet_03v3 ad=0 pd=0 as=0 ps=0 w=660 l=56
X954 VDD comp[40] NAND3_22/a_2506_982# VDD pfet_03v3 ad=0 pd=0 as=0 ps=0 w=660 l=56
X955 VDD comp[39] NAND3_22/a_2506_982# VDD pfet_03v3 ad=0 pd=0 as=0 ps=0 w=660 l=56
X956 NAND3_22/a_2506_982# comp[39] VDD VDD pfet_03v3 ad=0 pd=0 as=0 ps=0 w=660 l=56
X957 NAND3_22/a_2506_982# comp[39] VDD VDD pfet_03v3 ad=0 pd=0 as=0 ps=0 w=660 l=56
X958 VDD comp[39] NAND3_22/a_2506_982# VDD pfet_03v3 ad=0 pd=0 as=0 ps=0 w=660 l=56
X959 VDD comp[39] NAND3_22/a_2506_982# VDD pfet_03v3 ad=0 pd=0 as=0 ps=0 w=660 l=56
X960 VDD NAND3_22/a_2506_982# wl[40] VDD pfet_03v3 ad=0 pd=0 as=0.22308u ps=4.636m w=660 l=56
X961 wl[40] NAND3_22/a_2506_982# VDD VDD pfet_03v3 ad=0 pd=0 as=0 ps=0 w=660 l=56
X962 wl[40] NAND3_22/a_2506_982# VDD VDD pfet_03v3 ad=0 pd=0 as=0 ps=0 w=660 l=56
X963 VDD NAND3_22/a_2506_982# wl[40] VDD pfet_03v3 ad=0 pd=0 as=0 ps=0 w=660 l=56
X964 VDD NAND3_22/a_2506_982# wl[40] VDD pfet_03v3 ad=0 pd=0 as=0 ps=0 w=660 l=56
X965 VDD NAND3_22/a_n593_982# NAND3_22/a_2506_982# VDD pfet_03v3 ad=0 pd=0 as=0 ps=0 w=660 l=56
X966 NAND3_22/a_2506_982# NAND3_22/a_n593_982# VDD VDD pfet_03v3 ad=0 pd=0 as=0 ps=0 w=660 l=56
X967 NAND3_22/a_2506_982# NAND3_22/a_n593_982# VDD VDD pfet_03v3 ad=0 pd=0 as=0 ps=0 w=660 l=56
X968 VDD NAND3_22/a_n593_982# NAND3_22/a_2506_982# VDD pfet_03v3 ad=0 pd=0 as=0 ps=0 w=660 l=56
X969 VDD NAND3_22/a_n593_982# NAND3_22/a_2506_982# VDD pfet_03v3 ad=0 pd=0 as=0 ps=0 w=660 l=56
X970 NAND3_22/m1_n2243_n1314# comp[40] NAND3_22/m1_n3706_n1374# GND nfet_03v3 ad=0.28245u pd=6.192m as=0.28245u ps=6.192m w=508 l=56
X971 NAND3_22/m1_n2243_n1314# comp[40] NAND3_22/m1_n3706_n1374# GND nfet_03v3 ad=0 pd=0 as=0 ps=0 w=508 l=56
X972 NAND3_22/m1_n3706_n1374# comp[40] NAND3_22/m1_n2243_n1314# GND nfet_03v3 ad=0 pd=0 as=0 ps=0 w=508 l=56
X973 NAND3_22/m1_n3706_n1374# comp[40] NAND3_22/m1_n2243_n1314# GND nfet_03v3 ad=0 pd=0 as=0 ps=0 w=508 l=56
X974 GND comp[41] NAND3_22/a_n593_982# GND nfet_03v3 ad=0 pd=0 as=0.10566u ps=2.448m w=508 l=56
X975 GND comp[41] NAND3_22/a_n593_982# GND nfet_03v3 ad=0 pd=0 as=0 ps=0 w=508 l=56
X976 NAND3_22/a_n593_982# comp[41] GND GND nfet_03v3 ad=0 pd=0 as=0 ps=0 w=508 l=56
X977 NAND3_22/a_n593_982# comp[41] GND GND nfet_03v3 ad=0 pd=0 as=0 ps=0 w=508 l=56
X978 GND NAND3_22/a_n593_982# NAND3_22/m1_n2243_n1314# GND nfet_03v3 ad=0 pd=0 as=0 ps=0 w=508 l=56
X979 GND NAND3_22/a_n593_982# NAND3_22/m1_n2243_n1314# GND nfet_03v3 ad=0 pd=0 as=0 ps=0 w=508 l=56
X980 NAND3_22/m1_n2243_n1314# NAND3_22/a_n593_982# GND GND nfet_03v3 ad=0 pd=0 as=0 ps=0 w=508 l=56
X981 NAND3_22/m1_n2243_n1314# NAND3_22/a_n593_982# GND GND nfet_03v3 ad=0 pd=0 as=0 ps=0 w=508 l=56
X982 NAND3_22/m1_n3706_n1374# comp[39] NAND3_22/a_2506_982# GND nfet_03v3 ad=0 pd=0 as=0.10566u ps=2.448m w=508 l=56
X983 NAND3_22/m1_n3706_n1374# comp[39] NAND3_22/a_2506_982# GND nfet_03v3 ad=0 pd=0 as=0 ps=0 w=508 l=56
X984 NAND3_22/a_2506_982# comp[39] NAND3_22/m1_n3706_n1374# GND nfet_03v3 ad=0 pd=0 as=0 ps=0 w=508 l=56
X985 NAND3_22/a_2506_982# comp[39] NAND3_22/m1_n3706_n1374# GND nfet_03v3 ad=0 pd=0 as=0 ps=0 w=508 l=56
X986 GND NAND3_22/a_2506_982# wl[40] GND nfet_03v3 ad=0 pd=0 as=0.10566u ps=2.448m w=508 l=56
X987 GND NAND3_22/a_2506_982# wl[40] GND nfet_03v3 ad=0 pd=0 as=0 ps=0 w=508 l=56
X988 wl[40] NAND3_22/a_2506_982# GND GND nfet_03v3 ad=0 pd=0 as=0 ps=0 w=508 l=56
X989 wl[40] NAND3_22/a_2506_982# GND GND nfet_03v3 ad=0 pd=0 as=0 ps=0 w=508 l=56
X990 VDD comp[30] NAND3_33/a_n593_982# VDD pfet_03v3 ad=0 pd=0 as=0.22308u ps=4.636m w=660 l=56
X991 NAND3_33/a_n593_982# comp[30] VDD VDD pfet_03v3 ad=0 pd=0 as=0 ps=0 w=660 l=56
X992 NAND3_33/a_n593_982# comp[30] VDD VDD pfet_03v3 ad=0 pd=0 as=0 ps=0 w=660 l=56
X993 VDD comp[30] NAND3_33/a_n593_982# VDD pfet_03v3 ad=0 pd=0 as=0 ps=0 w=660 l=56
X994 VDD comp[30] NAND3_33/a_n593_982# VDD pfet_03v3 ad=0 pd=0 as=0 ps=0 w=660 l=56
X995 VDD comp[29] NAND3_33/a_2506_982# VDD pfet_03v3 ad=0 pd=0 as=0.66924u ps=0.01391 w=660 l=56
X996 NAND3_33/a_2506_982# comp[29] VDD VDD pfet_03v3 ad=0 pd=0 as=0 ps=0 w=660 l=56
X997 NAND3_33/a_2506_982# comp[29] VDD VDD pfet_03v3 ad=0 pd=0 as=0 ps=0 w=660 l=56
X998 VDD comp[29] NAND3_33/a_2506_982# VDD pfet_03v3 ad=0 pd=0 as=0 ps=0 w=660 l=56
X999 VDD comp[29] NAND3_33/a_2506_982# VDD pfet_03v3 ad=0 pd=0 as=0 ps=0 w=660 l=56
X1000 VDD comp[28] NAND3_33/a_2506_982# VDD pfet_03v3 ad=0 pd=0 as=0 ps=0 w=660 l=56
X1001 NAND3_33/a_2506_982# comp[28] VDD VDD pfet_03v3 ad=0 pd=0 as=0 ps=0 w=660 l=56
X1002 NAND3_33/a_2506_982# comp[28] VDD VDD pfet_03v3 ad=0 pd=0 as=0 ps=0 w=660 l=56
X1003 VDD comp[28] NAND3_33/a_2506_982# VDD pfet_03v3 ad=0 pd=0 as=0 ps=0 w=660 l=56
X1004 VDD comp[28] NAND3_33/a_2506_982# VDD pfet_03v3 ad=0 pd=0 as=0 ps=0 w=660 l=56
X1005 VDD NAND3_33/a_2506_982# wl[29] VDD pfet_03v3 ad=0 pd=0 as=0.22308u ps=4.636m w=660 l=56
X1006 wl[29] NAND3_33/a_2506_982# VDD VDD pfet_03v3 ad=0 pd=0 as=0 ps=0 w=660 l=56
X1007 wl[29] NAND3_33/a_2506_982# VDD VDD pfet_03v3 ad=0 pd=0 as=0 ps=0 w=660 l=56
X1008 VDD NAND3_33/a_2506_982# wl[29] VDD pfet_03v3 ad=0 pd=0 as=0 ps=0 w=660 l=56
X1009 VDD NAND3_33/a_2506_982# wl[29] VDD pfet_03v3 ad=0 pd=0 as=0 ps=0 w=660 l=56
X1010 VDD NAND3_33/a_n593_982# NAND3_33/a_2506_982# VDD pfet_03v3 ad=0 pd=0 as=0 ps=0 w=660 l=56
X1011 NAND3_33/a_2506_982# NAND3_33/a_n593_982# VDD VDD pfet_03v3 ad=0 pd=0 as=0 ps=0 w=660 l=56
X1012 NAND3_33/a_2506_982# NAND3_33/a_n593_982# VDD VDD pfet_03v3 ad=0 pd=0 as=0 ps=0 w=660 l=56
X1013 VDD NAND3_33/a_n593_982# NAND3_33/a_2506_982# VDD pfet_03v3 ad=0 pd=0 as=0 ps=0 w=660 l=56
X1014 VDD NAND3_33/a_n593_982# NAND3_33/a_2506_982# VDD pfet_03v3 ad=0 pd=0 as=0 ps=0 w=660 l=56
X1015 NAND3_33/m1_n2243_n1314# comp[29] NAND3_33/m1_n3706_n1374# GND nfet_03v3 ad=0.28245u pd=6.192m as=0.28245u ps=6.192m w=508 l=56
X1016 NAND3_33/m1_n2243_n1314# comp[29] NAND3_33/m1_n3706_n1374# GND nfet_03v3 ad=0 pd=0 as=0 ps=0 w=508 l=56
X1017 NAND3_33/m1_n3706_n1374# comp[29] NAND3_33/m1_n2243_n1314# GND nfet_03v3 ad=0 pd=0 as=0 ps=0 w=508 l=56
X1018 NAND3_33/m1_n3706_n1374# comp[29] NAND3_33/m1_n2243_n1314# GND nfet_03v3 ad=0 pd=0 as=0 ps=0 w=508 l=56
X1019 GND comp[30] NAND3_33/a_n593_982# GND nfet_03v3 ad=0 pd=0 as=0.10566u ps=2.448m w=508 l=56
X1020 GND comp[30] NAND3_33/a_n593_982# GND nfet_03v3 ad=0 pd=0 as=0 ps=0 w=508 l=56
X1021 NAND3_33/a_n593_982# comp[30] GND GND nfet_03v3 ad=0 pd=0 as=0 ps=0 w=508 l=56
X1022 NAND3_33/a_n593_982# comp[30] GND GND nfet_03v3 ad=0 pd=0 as=0 ps=0 w=508 l=56
X1023 GND NAND3_33/a_n593_982# NAND3_33/m1_n2243_n1314# GND nfet_03v3 ad=0 pd=0 as=0 ps=0 w=508 l=56
X1024 GND NAND3_33/a_n593_982# NAND3_33/m1_n2243_n1314# GND nfet_03v3 ad=0 pd=0 as=0 ps=0 w=508 l=56
X1025 NAND3_33/m1_n2243_n1314# NAND3_33/a_n593_982# GND GND nfet_03v3 ad=0 pd=0 as=0 ps=0 w=508 l=56
X1026 NAND3_33/m1_n2243_n1314# NAND3_33/a_n593_982# GND GND nfet_03v3 ad=0 pd=0 as=0 ps=0 w=508 l=56
X1027 NAND3_33/m1_n3706_n1374# comp[28] NAND3_33/a_2506_982# GND nfet_03v3 ad=0 pd=0 as=0.10566u ps=2.448m w=508 l=56
X1028 NAND3_33/m1_n3706_n1374# comp[28] NAND3_33/a_2506_982# GND nfet_03v3 ad=0 pd=0 as=0 ps=0 w=508 l=56
X1029 NAND3_33/a_2506_982# comp[28] NAND3_33/m1_n3706_n1374# GND nfet_03v3 ad=0 pd=0 as=0 ps=0 w=508 l=56
X1030 NAND3_33/a_2506_982# comp[28] NAND3_33/m1_n3706_n1374# GND nfet_03v3 ad=0 pd=0 as=0 ps=0 w=508 l=56
X1031 GND NAND3_33/a_2506_982# wl[29] GND nfet_03v3 ad=0 pd=0 as=0.10566u ps=2.448m w=508 l=56
X1032 GND NAND3_33/a_2506_982# wl[29] GND nfet_03v3 ad=0 pd=0 as=0 ps=0 w=508 l=56
X1033 wl[29] NAND3_33/a_2506_982# GND GND nfet_03v3 ad=0 pd=0 as=0 ps=0 w=508 l=56
X1034 wl[29] NAND3_33/a_2506_982# GND GND nfet_03v3 ad=0 pd=0 as=0 ps=0 w=508 l=56
X1035 VDD comp[19] NAND3_44/a_n593_982# VDD pfet_03v3 ad=0 pd=0 as=0.22308u ps=4.636m w=660 l=56
X1036 NAND3_44/a_n593_982# comp[19] VDD VDD pfet_03v3 ad=0 pd=0 as=0 ps=0 w=660 l=56
X1037 NAND3_44/a_n593_982# comp[19] VDD VDD pfet_03v3 ad=0 pd=0 as=0 ps=0 w=660 l=56
X1038 VDD comp[19] NAND3_44/a_n593_982# VDD pfet_03v3 ad=0 pd=0 as=0 ps=0 w=660 l=56
X1039 VDD comp[19] NAND3_44/a_n593_982# VDD pfet_03v3 ad=0 pd=0 as=0 ps=0 w=660 l=56
X1040 VDD comp[18] NAND3_44/a_2506_982# VDD pfet_03v3 ad=0 pd=0 as=0.66924u ps=0.01391 w=660 l=56
X1041 NAND3_44/a_2506_982# comp[18] VDD VDD pfet_03v3 ad=0 pd=0 as=0 ps=0 w=660 l=56
X1042 NAND3_44/a_2506_982# comp[18] VDD VDD pfet_03v3 ad=0 pd=0 as=0 ps=0 w=660 l=56
X1043 VDD comp[18] NAND3_44/a_2506_982# VDD pfet_03v3 ad=0 pd=0 as=0 ps=0 w=660 l=56
X1044 VDD comp[18] NAND3_44/a_2506_982# VDD pfet_03v3 ad=0 pd=0 as=0 ps=0 w=660 l=56
X1045 VDD comp[17] NAND3_44/a_2506_982# VDD pfet_03v3 ad=0 pd=0 as=0 ps=0 w=660 l=56
X1046 NAND3_44/a_2506_982# comp[17] VDD VDD pfet_03v3 ad=0 pd=0 as=0 ps=0 w=660 l=56
X1047 NAND3_44/a_2506_982# comp[17] VDD VDD pfet_03v3 ad=0 pd=0 as=0 ps=0 w=660 l=56
X1048 VDD comp[17] NAND3_44/a_2506_982# VDD pfet_03v3 ad=0 pd=0 as=0 ps=0 w=660 l=56
X1049 VDD comp[17] NAND3_44/a_2506_982# VDD pfet_03v3 ad=0 pd=0 as=0 ps=0 w=660 l=56
X1050 VDD NAND3_44/a_2506_982# wl[18] VDD pfet_03v3 ad=0 pd=0 as=0.22308u ps=4.636m w=660 l=56
X1051 wl[18] NAND3_44/a_2506_982# VDD VDD pfet_03v3 ad=0 pd=0 as=0 ps=0 w=660 l=56
X1052 wl[18] NAND3_44/a_2506_982# VDD VDD pfet_03v3 ad=0 pd=0 as=0 ps=0 w=660 l=56
X1053 VDD NAND3_44/a_2506_982# wl[18] VDD pfet_03v3 ad=0 pd=0 as=0 ps=0 w=660 l=56
X1054 VDD NAND3_44/a_2506_982# wl[18] VDD pfet_03v3 ad=0 pd=0 as=0 ps=0 w=660 l=56
X1055 VDD NAND3_44/a_n593_982# NAND3_44/a_2506_982# VDD pfet_03v3 ad=0 pd=0 as=0 ps=0 w=660 l=56
X1056 NAND3_44/a_2506_982# NAND3_44/a_n593_982# VDD VDD pfet_03v3 ad=0 pd=0 as=0 ps=0 w=660 l=56
X1057 NAND3_44/a_2506_982# NAND3_44/a_n593_982# VDD VDD pfet_03v3 ad=0 pd=0 as=0 ps=0 w=660 l=56
X1058 VDD NAND3_44/a_n593_982# NAND3_44/a_2506_982# VDD pfet_03v3 ad=0 pd=0 as=0 ps=0 w=660 l=56
X1059 VDD NAND3_44/a_n593_982# NAND3_44/a_2506_982# VDD pfet_03v3 ad=0 pd=0 as=0 ps=0 w=660 l=56
X1060 NAND3_44/m1_n2243_n1314# comp[18] NAND3_44/m1_n3706_n1374# GND nfet_03v3 ad=0.28245u pd=6.192m as=0.28245u ps=6.192m w=508 l=56
X1061 NAND3_44/m1_n2243_n1314# comp[18] NAND3_44/m1_n3706_n1374# GND nfet_03v3 ad=0 pd=0 as=0 ps=0 w=508 l=56
X1062 NAND3_44/m1_n3706_n1374# comp[18] NAND3_44/m1_n2243_n1314# GND nfet_03v3 ad=0 pd=0 as=0 ps=0 w=508 l=56
X1063 NAND3_44/m1_n3706_n1374# comp[18] NAND3_44/m1_n2243_n1314# GND nfet_03v3 ad=0 pd=0 as=0 ps=0 w=508 l=56
X1064 GND comp[19] NAND3_44/a_n593_982# GND nfet_03v3 ad=0 pd=0 as=0.10566u ps=2.448m w=508 l=56
X1065 GND comp[19] NAND3_44/a_n593_982# GND nfet_03v3 ad=0 pd=0 as=0 ps=0 w=508 l=56
X1066 NAND3_44/a_n593_982# comp[19] GND GND nfet_03v3 ad=0 pd=0 as=0 ps=0 w=508 l=56
X1067 NAND3_44/a_n593_982# comp[19] GND GND nfet_03v3 ad=0 pd=0 as=0 ps=0 w=508 l=56
X1068 GND NAND3_44/a_n593_982# NAND3_44/m1_n2243_n1314# GND nfet_03v3 ad=0 pd=0 as=0 ps=0 w=508 l=56
X1069 GND NAND3_44/a_n593_982# NAND3_44/m1_n2243_n1314# GND nfet_03v3 ad=0 pd=0 as=0 ps=0 w=508 l=56
X1070 NAND3_44/m1_n2243_n1314# NAND3_44/a_n593_982# GND GND nfet_03v3 ad=0 pd=0 as=0 ps=0 w=508 l=56
X1071 NAND3_44/m1_n2243_n1314# NAND3_44/a_n593_982# GND GND nfet_03v3 ad=0 pd=0 as=0 ps=0 w=508 l=56
X1072 NAND3_44/m1_n3706_n1374# comp[17] NAND3_44/a_2506_982# GND nfet_03v3 ad=0 pd=0 as=0.10566u ps=2.448m w=508 l=56
X1073 NAND3_44/m1_n3706_n1374# comp[17] NAND3_44/a_2506_982# GND nfet_03v3 ad=0 pd=0 as=0 ps=0 w=508 l=56
X1074 NAND3_44/a_2506_982# comp[17] NAND3_44/m1_n3706_n1374# GND nfet_03v3 ad=0 pd=0 as=0 ps=0 w=508 l=56
X1075 NAND3_44/a_2506_982# comp[17] NAND3_44/m1_n3706_n1374# GND nfet_03v3 ad=0 pd=0 as=0 ps=0 w=508 l=56
X1076 GND NAND3_44/a_2506_982# wl[18] GND nfet_03v3 ad=0 pd=0 as=0.10566u ps=2.448m w=508 l=56
X1077 GND NAND3_44/a_2506_982# wl[18] GND nfet_03v3 ad=0 pd=0 as=0 ps=0 w=508 l=56
X1078 wl[18] NAND3_44/a_2506_982# GND GND nfet_03v3 ad=0 pd=0 as=0 ps=0 w=508 l=56
X1079 wl[18] NAND3_44/a_2506_982# GND GND nfet_03v3 ad=0 pd=0 as=0 ps=0 w=508 l=56
X1080 VDD comp[8] NAND3_55/a_n593_982# VDD pfet_03v3 ad=0 pd=0 as=0.22308u ps=4.636m w=660 l=56
X1081 NAND3_55/a_n593_982# comp[8] VDD VDD pfet_03v3 ad=0 pd=0 as=0 ps=0 w=660 l=56
X1082 NAND3_55/a_n593_982# comp[8] VDD VDD pfet_03v3 ad=0 pd=0 as=0 ps=0 w=660 l=56
X1083 VDD comp[8] NAND3_55/a_n593_982# VDD pfet_03v3 ad=0 pd=0 as=0 ps=0 w=660 l=56
X1084 VDD comp[8] NAND3_55/a_n593_982# VDD pfet_03v3 ad=0 pd=0 as=0 ps=0 w=660 l=56
X1085 VDD comp[7] NAND3_55/a_2506_982# VDD pfet_03v3 ad=0 pd=0 as=0.66924u ps=0.01391 w=660 l=56
X1086 NAND3_55/a_2506_982# comp[7] VDD VDD pfet_03v3 ad=0 pd=0 as=0 ps=0 w=660 l=56
X1087 NAND3_55/a_2506_982# comp[7] VDD VDD pfet_03v3 ad=0 pd=0 as=0 ps=0 w=660 l=56
X1088 VDD comp[7] NAND3_55/a_2506_982# VDD pfet_03v3 ad=0 pd=0 as=0 ps=0 w=660 l=56
X1089 VDD comp[7] NAND3_55/a_2506_982# VDD pfet_03v3 ad=0 pd=0 as=0 ps=0 w=660 l=56
X1090 VDD comp[6] NAND3_55/a_2506_982# VDD pfet_03v3 ad=0 pd=0 as=0 ps=0 w=660 l=56
X1091 NAND3_55/a_2506_982# comp[6] VDD VDD pfet_03v3 ad=0 pd=0 as=0 ps=0 w=660 l=56
X1092 NAND3_55/a_2506_982# comp[6] VDD VDD pfet_03v3 ad=0 pd=0 as=0 ps=0 w=660 l=56
X1093 VDD comp[6] NAND3_55/a_2506_982# VDD pfet_03v3 ad=0 pd=0 as=0 ps=0 w=660 l=56
X1094 VDD comp[6] NAND3_55/a_2506_982# VDD pfet_03v3 ad=0 pd=0 as=0 ps=0 w=660 l=56
X1095 VDD NAND3_55/a_2506_982# wl[7] VDD pfet_03v3 ad=0 pd=0 as=0.22308u ps=4.636m w=660 l=56
X1096 wl[7] NAND3_55/a_2506_982# VDD VDD pfet_03v3 ad=0 pd=0 as=0 ps=0 w=660 l=56
X1097 wl[7] NAND3_55/a_2506_982# VDD VDD pfet_03v3 ad=0 pd=0 as=0 ps=0 w=660 l=56
X1098 VDD NAND3_55/a_2506_982# wl[7] VDD pfet_03v3 ad=0 pd=0 as=0 ps=0 w=660 l=56
X1099 VDD NAND3_55/a_2506_982# wl[7] VDD pfet_03v3 ad=0 pd=0 as=0 ps=0 w=660 l=56
X1100 VDD NAND3_55/a_n593_982# NAND3_55/a_2506_982# VDD pfet_03v3 ad=0 pd=0 as=0 ps=0 w=660 l=56
X1101 NAND3_55/a_2506_982# NAND3_55/a_n593_982# VDD VDD pfet_03v3 ad=0 pd=0 as=0 ps=0 w=660 l=56
X1102 NAND3_55/a_2506_982# NAND3_55/a_n593_982# VDD VDD pfet_03v3 ad=0 pd=0 as=0 ps=0 w=660 l=56
X1103 VDD NAND3_55/a_n593_982# NAND3_55/a_2506_982# VDD pfet_03v3 ad=0 pd=0 as=0 ps=0 w=660 l=56
X1104 VDD NAND3_55/a_n593_982# NAND3_55/a_2506_982# VDD pfet_03v3 ad=0 pd=0 as=0 ps=0 w=660 l=56
X1105 NAND3_55/m1_n2243_n1314# comp[7] NAND3_55/m1_n3706_n1374# GND nfet_03v3 ad=0.28245u pd=6.192m as=0.28245u ps=6.192m w=508 l=56
X1106 NAND3_55/m1_n2243_n1314# comp[7] NAND3_55/m1_n3706_n1374# GND nfet_03v3 ad=0 pd=0 as=0 ps=0 w=508 l=56
X1107 NAND3_55/m1_n3706_n1374# comp[7] NAND3_55/m1_n2243_n1314# GND nfet_03v3 ad=0 pd=0 as=0 ps=0 w=508 l=56
X1108 NAND3_55/m1_n3706_n1374# comp[7] NAND3_55/m1_n2243_n1314# GND nfet_03v3 ad=0 pd=0 as=0 ps=0 w=508 l=56
X1109 GND comp[8] NAND3_55/a_n593_982# GND nfet_03v3 ad=0 pd=0 as=0.10566u ps=2.448m w=508 l=56
X1110 GND comp[8] NAND3_55/a_n593_982# GND nfet_03v3 ad=0 pd=0 as=0 ps=0 w=508 l=56
X1111 NAND3_55/a_n593_982# comp[8] GND GND nfet_03v3 ad=0 pd=0 as=0 ps=0 w=508 l=56
X1112 NAND3_55/a_n593_982# comp[8] GND GND nfet_03v3 ad=0 pd=0 as=0 ps=0 w=508 l=56
X1113 GND NAND3_55/a_n593_982# NAND3_55/m1_n2243_n1314# GND nfet_03v3 ad=0 pd=0 as=0 ps=0 w=508 l=56
X1114 GND NAND3_55/a_n593_982# NAND3_55/m1_n2243_n1314# GND nfet_03v3 ad=0 pd=0 as=0 ps=0 w=508 l=56
X1115 NAND3_55/m1_n2243_n1314# NAND3_55/a_n593_982# GND GND nfet_03v3 ad=0 pd=0 as=0 ps=0 w=508 l=56
X1116 NAND3_55/m1_n2243_n1314# NAND3_55/a_n593_982# GND GND nfet_03v3 ad=0 pd=0 as=0 ps=0 w=508 l=56
X1117 NAND3_55/m1_n3706_n1374# comp[6] NAND3_55/a_2506_982# GND nfet_03v3 ad=0 pd=0 as=0.10566u ps=2.448m w=508 l=56
X1118 NAND3_55/m1_n3706_n1374# comp[6] NAND3_55/a_2506_982# GND nfet_03v3 ad=0 pd=0 as=0 ps=0 w=508 l=56
X1119 NAND3_55/a_2506_982# comp[6] NAND3_55/m1_n3706_n1374# GND nfet_03v3 ad=0 pd=0 as=0 ps=0 w=508 l=56
X1120 NAND3_55/a_2506_982# comp[6] NAND3_55/m1_n3706_n1374# GND nfet_03v3 ad=0 pd=0 as=0 ps=0 w=508 l=56
X1121 GND NAND3_55/a_2506_982# wl[7] GND nfet_03v3 ad=0 pd=0 as=0.10566u ps=2.448m w=508 l=56
X1122 GND NAND3_55/a_2506_982# wl[7] GND nfet_03v3 ad=0 pd=0 as=0 ps=0 w=508 l=56
X1123 wl[7] NAND3_55/a_2506_982# GND GND nfet_03v3 ad=0 pd=0 as=0 ps=0 w=508 l=56
X1124 wl[7] NAND3_55/a_2506_982# GND GND nfet_03v3 ad=0 pd=0 as=0 ps=0 w=508 l=56
X1125 VDD comp[61] NAND3_2/a_n593_982# VDD pfet_03v3 ad=0 pd=0 as=0.22308u ps=4.636m w=660 l=56
X1126 NAND3_2/a_n593_982# comp[61] VDD VDD pfet_03v3 ad=0 pd=0 as=0 ps=0 w=660 l=56
X1127 NAND3_2/a_n593_982# comp[61] VDD VDD pfet_03v3 ad=0 pd=0 as=0 ps=0 w=660 l=56
X1128 VDD comp[61] NAND3_2/a_n593_982# VDD pfet_03v3 ad=0 pd=0 as=0 ps=0 w=660 l=56
X1129 VDD comp[61] NAND3_2/a_n593_982# VDD pfet_03v3 ad=0 pd=0 as=0 ps=0 w=660 l=56
X1130 VDD comp[60] NAND3_2/a_2506_982# VDD pfet_03v3 ad=0 pd=0 as=0.66924u ps=0.01391 w=660 l=56
X1131 NAND3_2/a_2506_982# comp[60] VDD VDD pfet_03v3 ad=0 pd=0 as=0 ps=0 w=660 l=56
X1132 NAND3_2/a_2506_982# comp[60] VDD VDD pfet_03v3 ad=0 pd=0 as=0 ps=0 w=660 l=56
X1133 VDD comp[60] NAND3_2/a_2506_982# VDD pfet_03v3 ad=0 pd=0 as=0 ps=0 w=660 l=56
X1134 VDD comp[60] NAND3_2/a_2506_982# VDD pfet_03v3 ad=0 pd=0 as=0 ps=0 w=660 l=56
X1135 VDD comp[59] NAND3_2/a_2506_982# VDD pfet_03v3 ad=0 pd=0 as=0 ps=0 w=660 l=56
X1136 NAND3_2/a_2506_982# comp[59] VDD VDD pfet_03v3 ad=0 pd=0 as=0 ps=0 w=660 l=56
X1137 NAND3_2/a_2506_982# comp[59] VDD VDD pfet_03v3 ad=0 pd=0 as=0 ps=0 w=660 l=56
X1138 VDD comp[59] NAND3_2/a_2506_982# VDD pfet_03v3 ad=0 pd=0 as=0 ps=0 w=660 l=56
X1139 VDD comp[59] NAND3_2/a_2506_982# VDD pfet_03v3 ad=0 pd=0 as=0 ps=0 w=660 l=56
X1140 VDD NAND3_2/a_2506_982# wl[60] VDD pfet_03v3 ad=0 pd=0 as=0.22308u ps=4.636m w=660 l=56
X1141 wl[60] NAND3_2/a_2506_982# VDD VDD pfet_03v3 ad=0 pd=0 as=0 ps=0 w=660 l=56
X1142 wl[60] NAND3_2/a_2506_982# VDD VDD pfet_03v3 ad=0 pd=0 as=0 ps=0 w=660 l=56
X1143 VDD NAND3_2/a_2506_982# wl[60] VDD pfet_03v3 ad=0 pd=0 as=0 ps=0 w=660 l=56
X1144 VDD NAND3_2/a_2506_982# wl[60] VDD pfet_03v3 ad=0 pd=0 as=0 ps=0 w=660 l=56
X1145 VDD NAND3_2/a_n593_982# NAND3_2/a_2506_982# VDD pfet_03v3 ad=0 pd=0 as=0 ps=0 w=660 l=56
X1146 NAND3_2/a_2506_982# NAND3_2/a_n593_982# VDD VDD pfet_03v3 ad=0 pd=0 as=0 ps=0 w=660 l=56
X1147 NAND3_2/a_2506_982# NAND3_2/a_n593_982# VDD VDD pfet_03v3 ad=0 pd=0 as=0 ps=0 w=660 l=56
X1148 VDD NAND3_2/a_n593_982# NAND3_2/a_2506_982# VDD pfet_03v3 ad=0 pd=0 as=0 ps=0 w=660 l=56
X1149 VDD NAND3_2/a_n593_982# NAND3_2/a_2506_982# VDD pfet_03v3 ad=0 pd=0 as=0 ps=0 w=660 l=56
X1150 NAND3_2/m1_n2243_n1314# comp[60] NAND3_2/m1_n3706_n1374# GND nfet_03v3 ad=0.28245u pd=6.192m as=0.28245u ps=6.192m w=508 l=56
X1151 NAND3_2/m1_n2243_n1314# comp[60] NAND3_2/m1_n3706_n1374# GND nfet_03v3 ad=0 pd=0 as=0 ps=0 w=508 l=56
X1152 NAND3_2/m1_n3706_n1374# comp[60] NAND3_2/m1_n2243_n1314# GND nfet_03v3 ad=0 pd=0 as=0 ps=0 w=508 l=56
X1153 NAND3_2/m1_n3706_n1374# comp[60] NAND3_2/m1_n2243_n1314# GND nfet_03v3 ad=0 pd=0 as=0 ps=0 w=508 l=56
X1154 GND comp[61] NAND3_2/a_n593_982# GND nfet_03v3 ad=0 pd=0 as=0.10566u ps=2.448m w=508 l=56
X1155 GND comp[61] NAND3_2/a_n593_982# GND nfet_03v3 ad=0 pd=0 as=0 ps=0 w=508 l=56
X1156 NAND3_2/a_n593_982# comp[61] GND GND nfet_03v3 ad=0 pd=0 as=0 ps=0 w=508 l=56
X1157 NAND3_2/a_n593_982# comp[61] GND GND nfet_03v3 ad=0 pd=0 as=0 ps=0 w=508 l=56
X1158 GND NAND3_2/a_n593_982# NAND3_2/m1_n2243_n1314# GND nfet_03v3 ad=0 pd=0 as=0 ps=0 w=508 l=56
X1159 GND NAND3_2/a_n593_982# NAND3_2/m1_n2243_n1314# GND nfet_03v3 ad=0 pd=0 as=0 ps=0 w=508 l=56
X1160 NAND3_2/m1_n2243_n1314# NAND3_2/a_n593_982# GND GND nfet_03v3 ad=0 pd=0 as=0 ps=0 w=508 l=56
X1161 NAND3_2/m1_n2243_n1314# NAND3_2/a_n593_982# GND GND nfet_03v3 ad=0 pd=0 as=0 ps=0 w=508 l=56
X1162 NAND3_2/m1_n3706_n1374# comp[59] NAND3_2/a_2506_982# GND nfet_03v3 ad=0 pd=0 as=0.10566u ps=2.448m w=508 l=56
X1163 NAND3_2/m1_n3706_n1374# comp[59] NAND3_2/a_2506_982# GND nfet_03v3 ad=0 pd=0 as=0 ps=0 w=508 l=56
X1164 NAND3_2/a_2506_982# comp[59] NAND3_2/m1_n3706_n1374# GND nfet_03v3 ad=0 pd=0 as=0 ps=0 w=508 l=56
X1165 NAND3_2/a_2506_982# comp[59] NAND3_2/m1_n3706_n1374# GND nfet_03v3 ad=0 pd=0 as=0 ps=0 w=508 l=56
X1166 GND NAND3_2/a_2506_982# wl[60] GND nfet_03v3 ad=0 pd=0 as=0.10566u ps=2.448m w=508 l=56
X1167 GND NAND3_2/a_2506_982# wl[60] GND nfet_03v3 ad=0 pd=0 as=0 ps=0 w=508 l=56
X1168 wl[60] NAND3_2/a_2506_982# GND GND nfet_03v3 ad=0 pd=0 as=0 ps=0 w=508 l=56
X1169 wl[60] NAND3_2/a_2506_982# GND GND nfet_03v3 ad=0 pd=0 as=0 ps=0 w=508 l=56
X1170 VDD comp[51] NAND3_12/a_n593_982# VDD pfet_03v3 ad=0 pd=0 as=0.22308u ps=4.636m w=660 l=56
X1171 NAND3_12/a_n593_982# comp[51] VDD VDD pfet_03v3 ad=0 pd=0 as=0 ps=0 w=660 l=56
X1172 NAND3_12/a_n593_982# comp[51] VDD VDD pfet_03v3 ad=0 pd=0 as=0 ps=0 w=660 l=56
X1173 VDD comp[51] NAND3_12/a_n593_982# VDD pfet_03v3 ad=0 pd=0 as=0 ps=0 w=660 l=56
X1174 VDD comp[51] NAND3_12/a_n593_982# VDD pfet_03v3 ad=0 pd=0 as=0 ps=0 w=660 l=56
X1175 VDD comp[50] NAND3_12/a_2506_982# VDD pfet_03v3 ad=0 pd=0 as=0.66924u ps=0.01391 w=660 l=56
X1176 NAND3_12/a_2506_982# comp[50] VDD VDD pfet_03v3 ad=0 pd=0 as=0 ps=0 w=660 l=56
X1177 NAND3_12/a_2506_982# comp[50] VDD VDD pfet_03v3 ad=0 pd=0 as=0 ps=0 w=660 l=56
X1178 VDD comp[50] NAND3_12/a_2506_982# VDD pfet_03v3 ad=0 pd=0 as=0 ps=0 w=660 l=56
X1179 VDD comp[50] NAND3_12/a_2506_982# VDD pfet_03v3 ad=0 pd=0 as=0 ps=0 w=660 l=56
X1180 VDD comp[49] NAND3_12/a_2506_982# VDD pfet_03v3 ad=0 pd=0 as=0 ps=0 w=660 l=56
X1181 NAND3_12/a_2506_982# comp[49] VDD VDD pfet_03v3 ad=0 pd=0 as=0 ps=0 w=660 l=56
X1182 NAND3_12/a_2506_982# comp[49] VDD VDD pfet_03v3 ad=0 pd=0 as=0 ps=0 w=660 l=56
X1183 VDD comp[49] NAND3_12/a_2506_982# VDD pfet_03v3 ad=0 pd=0 as=0 ps=0 w=660 l=56
X1184 VDD comp[49] NAND3_12/a_2506_982# VDD pfet_03v3 ad=0 pd=0 as=0 ps=0 w=660 l=56
X1185 VDD NAND3_12/a_2506_982# wl[50] VDD pfet_03v3 ad=0 pd=0 as=0.22308u ps=4.636m w=660 l=56
X1186 wl[50] NAND3_12/a_2506_982# VDD VDD pfet_03v3 ad=0 pd=0 as=0 ps=0 w=660 l=56
X1187 wl[50] NAND3_12/a_2506_982# VDD VDD pfet_03v3 ad=0 pd=0 as=0 ps=0 w=660 l=56
X1188 VDD NAND3_12/a_2506_982# wl[50] VDD pfet_03v3 ad=0 pd=0 as=0 ps=0 w=660 l=56
X1189 VDD NAND3_12/a_2506_982# wl[50] VDD pfet_03v3 ad=0 pd=0 as=0 ps=0 w=660 l=56
X1190 VDD NAND3_12/a_n593_982# NAND3_12/a_2506_982# VDD pfet_03v3 ad=0 pd=0 as=0 ps=0 w=660 l=56
X1191 NAND3_12/a_2506_982# NAND3_12/a_n593_982# VDD VDD pfet_03v3 ad=0 pd=0 as=0 ps=0 w=660 l=56
X1192 NAND3_12/a_2506_982# NAND3_12/a_n593_982# VDD VDD pfet_03v3 ad=0 pd=0 as=0 ps=0 w=660 l=56
X1193 VDD NAND3_12/a_n593_982# NAND3_12/a_2506_982# VDD pfet_03v3 ad=0 pd=0 as=0 ps=0 w=660 l=56
X1194 VDD NAND3_12/a_n593_982# NAND3_12/a_2506_982# VDD pfet_03v3 ad=0 pd=0 as=0 ps=0 w=660 l=56
X1195 NAND3_12/m1_n2243_n1314# comp[50] NAND3_12/m1_n3706_n1374# GND nfet_03v3 ad=0.28245u pd=6.192m as=0.28245u ps=6.192m w=508 l=56
X1196 NAND3_12/m1_n2243_n1314# comp[50] NAND3_12/m1_n3706_n1374# GND nfet_03v3 ad=0 pd=0 as=0 ps=0 w=508 l=56
X1197 NAND3_12/m1_n3706_n1374# comp[50] NAND3_12/m1_n2243_n1314# GND nfet_03v3 ad=0 pd=0 as=0 ps=0 w=508 l=56
X1198 NAND3_12/m1_n3706_n1374# comp[50] NAND3_12/m1_n2243_n1314# GND nfet_03v3 ad=0 pd=0 as=0 ps=0 w=508 l=56
X1199 GND comp[51] NAND3_12/a_n593_982# GND nfet_03v3 ad=0 pd=0 as=0.10566u ps=2.448m w=508 l=56
X1200 GND comp[51] NAND3_12/a_n593_982# GND nfet_03v3 ad=0 pd=0 as=0 ps=0 w=508 l=56
X1201 NAND3_12/a_n593_982# comp[51] GND GND nfet_03v3 ad=0 pd=0 as=0 ps=0 w=508 l=56
X1202 NAND3_12/a_n593_982# comp[51] GND GND nfet_03v3 ad=0 pd=0 as=0 ps=0 w=508 l=56
X1203 GND NAND3_12/a_n593_982# NAND3_12/m1_n2243_n1314# GND nfet_03v3 ad=0 pd=0 as=0 ps=0 w=508 l=56
X1204 GND NAND3_12/a_n593_982# NAND3_12/m1_n2243_n1314# GND nfet_03v3 ad=0 pd=0 as=0 ps=0 w=508 l=56
X1205 NAND3_12/m1_n2243_n1314# NAND3_12/a_n593_982# GND GND nfet_03v3 ad=0 pd=0 as=0 ps=0 w=508 l=56
X1206 NAND3_12/m1_n2243_n1314# NAND3_12/a_n593_982# GND GND nfet_03v3 ad=0 pd=0 as=0 ps=0 w=508 l=56
X1207 NAND3_12/m1_n3706_n1374# comp[49] NAND3_12/a_2506_982# GND nfet_03v3 ad=0 pd=0 as=0.10566u ps=2.448m w=508 l=56
X1208 NAND3_12/m1_n3706_n1374# comp[49] NAND3_12/a_2506_982# GND nfet_03v3 ad=0 pd=0 as=0 ps=0 w=508 l=56
X1209 NAND3_12/a_2506_982# comp[49] NAND3_12/m1_n3706_n1374# GND nfet_03v3 ad=0 pd=0 as=0 ps=0 w=508 l=56
X1210 NAND3_12/a_2506_982# comp[49] NAND3_12/m1_n3706_n1374# GND nfet_03v3 ad=0 pd=0 as=0 ps=0 w=508 l=56
X1211 GND NAND3_12/a_2506_982# wl[50] GND nfet_03v3 ad=0 pd=0 as=0.10566u ps=2.448m w=508 l=56
X1212 GND NAND3_12/a_2506_982# wl[50] GND nfet_03v3 ad=0 pd=0 as=0 ps=0 w=508 l=56
X1213 wl[50] NAND3_12/a_2506_982# GND GND nfet_03v3 ad=0 pd=0 as=0 ps=0 w=508 l=56
X1214 wl[50] NAND3_12/a_2506_982# GND GND nfet_03v3 ad=0 pd=0 as=0 ps=0 w=508 l=56
X1215 VDD comp[40] NAND3_23/a_n593_982# VDD pfet_03v3 ad=0 pd=0 as=0.22308u ps=4.636m w=660 l=56
X1216 NAND3_23/a_n593_982# comp[40] VDD VDD pfet_03v3 ad=0 pd=0 as=0 ps=0 w=660 l=56
X1217 NAND3_23/a_n593_982# comp[40] VDD VDD pfet_03v3 ad=0 pd=0 as=0 ps=0 w=660 l=56
X1218 VDD comp[40] NAND3_23/a_n593_982# VDD pfet_03v3 ad=0 pd=0 as=0 ps=0 w=660 l=56
X1219 VDD comp[40] NAND3_23/a_n593_982# VDD pfet_03v3 ad=0 pd=0 as=0 ps=0 w=660 l=56
X1220 VDD comp[39] NAND3_23/a_2506_982# VDD pfet_03v3 ad=0 pd=0 as=0.66924u ps=0.01391 w=660 l=56
X1221 NAND3_23/a_2506_982# comp[39] VDD VDD pfet_03v3 ad=0 pd=0 as=0 ps=0 w=660 l=56
X1222 NAND3_23/a_2506_982# comp[39] VDD VDD pfet_03v3 ad=0 pd=0 as=0 ps=0 w=660 l=56
X1223 VDD comp[39] NAND3_23/a_2506_982# VDD pfet_03v3 ad=0 pd=0 as=0 ps=0 w=660 l=56
X1224 VDD comp[39] NAND3_23/a_2506_982# VDD pfet_03v3 ad=0 pd=0 as=0 ps=0 w=660 l=56
X1225 VDD comp[38] NAND3_23/a_2506_982# VDD pfet_03v3 ad=0 pd=0 as=0 ps=0 w=660 l=56
X1226 NAND3_23/a_2506_982# comp[38] VDD VDD pfet_03v3 ad=0 pd=0 as=0 ps=0 w=660 l=56
X1227 NAND3_23/a_2506_982# comp[38] VDD VDD pfet_03v3 ad=0 pd=0 as=0 ps=0 w=660 l=56
X1228 VDD comp[38] NAND3_23/a_2506_982# VDD pfet_03v3 ad=0 pd=0 as=0 ps=0 w=660 l=56
X1229 VDD comp[38] NAND3_23/a_2506_982# VDD pfet_03v3 ad=0 pd=0 as=0 ps=0 w=660 l=56
X1230 VDD NAND3_23/a_2506_982# wl[39] VDD pfet_03v3 ad=0 pd=0 as=0.22308u ps=4.636m w=660 l=56
X1231 wl[39] NAND3_23/a_2506_982# VDD VDD pfet_03v3 ad=0 pd=0 as=0 ps=0 w=660 l=56
X1232 wl[39] NAND3_23/a_2506_982# VDD VDD pfet_03v3 ad=0 pd=0 as=0 ps=0 w=660 l=56
X1233 VDD NAND3_23/a_2506_982# wl[39] VDD pfet_03v3 ad=0 pd=0 as=0 ps=0 w=660 l=56
X1234 VDD NAND3_23/a_2506_982# wl[39] VDD pfet_03v3 ad=0 pd=0 as=0 ps=0 w=660 l=56
X1235 VDD NAND3_23/a_n593_982# NAND3_23/a_2506_982# VDD pfet_03v3 ad=0 pd=0 as=0 ps=0 w=660 l=56
X1236 NAND3_23/a_2506_982# NAND3_23/a_n593_982# VDD VDD pfet_03v3 ad=0 pd=0 as=0 ps=0 w=660 l=56
X1237 NAND3_23/a_2506_982# NAND3_23/a_n593_982# VDD VDD pfet_03v3 ad=0 pd=0 as=0 ps=0 w=660 l=56
X1238 VDD NAND3_23/a_n593_982# NAND3_23/a_2506_982# VDD pfet_03v3 ad=0 pd=0 as=0 ps=0 w=660 l=56
X1239 VDD NAND3_23/a_n593_982# NAND3_23/a_2506_982# VDD pfet_03v3 ad=0 pd=0 as=0 ps=0 w=660 l=56
X1240 NAND3_23/m1_n2243_n1314# comp[39] NAND3_23/m1_n3706_n1374# GND nfet_03v3 ad=0.28245u pd=6.192m as=0.28245u ps=6.192m w=508 l=56
X1241 NAND3_23/m1_n2243_n1314# comp[39] NAND3_23/m1_n3706_n1374# GND nfet_03v3 ad=0 pd=0 as=0 ps=0 w=508 l=56
X1242 NAND3_23/m1_n3706_n1374# comp[39] NAND3_23/m1_n2243_n1314# GND nfet_03v3 ad=0 pd=0 as=0 ps=0 w=508 l=56
X1243 NAND3_23/m1_n3706_n1374# comp[39] NAND3_23/m1_n2243_n1314# GND nfet_03v3 ad=0 pd=0 as=0 ps=0 w=508 l=56
X1244 GND comp[40] NAND3_23/a_n593_982# GND nfet_03v3 ad=0 pd=0 as=0.10566u ps=2.448m w=508 l=56
X1245 GND comp[40] NAND3_23/a_n593_982# GND nfet_03v3 ad=0 pd=0 as=0 ps=0 w=508 l=56
X1246 NAND3_23/a_n593_982# comp[40] GND GND nfet_03v3 ad=0 pd=0 as=0 ps=0 w=508 l=56
X1247 NAND3_23/a_n593_982# comp[40] GND GND nfet_03v3 ad=0 pd=0 as=0 ps=0 w=508 l=56
X1248 GND NAND3_23/a_n593_982# NAND3_23/m1_n2243_n1314# GND nfet_03v3 ad=0 pd=0 as=0 ps=0 w=508 l=56
X1249 GND NAND3_23/a_n593_982# NAND3_23/m1_n2243_n1314# GND nfet_03v3 ad=0 pd=0 as=0 ps=0 w=508 l=56
X1250 NAND3_23/m1_n2243_n1314# NAND3_23/a_n593_982# GND GND nfet_03v3 ad=0 pd=0 as=0 ps=0 w=508 l=56
X1251 NAND3_23/m1_n2243_n1314# NAND3_23/a_n593_982# GND GND nfet_03v3 ad=0 pd=0 as=0 ps=0 w=508 l=56
X1252 NAND3_23/m1_n3706_n1374# comp[38] NAND3_23/a_2506_982# GND nfet_03v3 ad=0 pd=0 as=0.10566u ps=2.448m w=508 l=56
X1253 NAND3_23/m1_n3706_n1374# comp[38] NAND3_23/a_2506_982# GND nfet_03v3 ad=0 pd=0 as=0 ps=0 w=508 l=56
X1254 NAND3_23/a_2506_982# comp[38] NAND3_23/m1_n3706_n1374# GND nfet_03v3 ad=0 pd=0 as=0 ps=0 w=508 l=56
X1255 NAND3_23/a_2506_982# comp[38] NAND3_23/m1_n3706_n1374# GND nfet_03v3 ad=0 pd=0 as=0 ps=0 w=508 l=56
X1256 GND NAND3_23/a_2506_982# wl[39] GND nfet_03v3 ad=0 pd=0 as=0.10566u ps=2.448m w=508 l=56
X1257 GND NAND3_23/a_2506_982# wl[39] GND nfet_03v3 ad=0 pd=0 as=0 ps=0 w=508 l=56
X1258 wl[39] NAND3_23/a_2506_982# GND GND nfet_03v3 ad=0 pd=0 as=0 ps=0 w=508 l=56
X1259 wl[39] NAND3_23/a_2506_982# GND GND nfet_03v3 ad=0 pd=0 as=0 ps=0 w=508 l=56
X1260 VDD comp[29] NAND3_34/a_n593_982# VDD pfet_03v3 ad=0 pd=0 as=0.22308u ps=4.636m w=660 l=56
X1261 NAND3_34/a_n593_982# comp[29] VDD VDD pfet_03v3 ad=0 pd=0 as=0 ps=0 w=660 l=56
X1262 NAND3_34/a_n593_982# comp[29] VDD VDD pfet_03v3 ad=0 pd=0 as=0 ps=0 w=660 l=56
X1263 VDD comp[29] NAND3_34/a_n593_982# VDD pfet_03v3 ad=0 pd=0 as=0 ps=0 w=660 l=56
X1264 VDD comp[29] NAND3_34/a_n593_982# VDD pfet_03v3 ad=0 pd=0 as=0 ps=0 w=660 l=56
X1265 VDD comp[28] NAND3_34/a_2506_982# VDD pfet_03v3 ad=0 pd=0 as=0.66924u ps=0.01391 w=660 l=56
X1266 NAND3_34/a_2506_982# comp[28] VDD VDD pfet_03v3 ad=0 pd=0 as=0 ps=0 w=660 l=56
X1267 NAND3_34/a_2506_982# comp[28] VDD VDD pfet_03v3 ad=0 pd=0 as=0 ps=0 w=660 l=56
X1268 VDD comp[28] NAND3_34/a_2506_982# VDD pfet_03v3 ad=0 pd=0 as=0 ps=0 w=660 l=56
X1269 VDD comp[28] NAND3_34/a_2506_982# VDD pfet_03v3 ad=0 pd=0 as=0 ps=0 w=660 l=56
X1270 VDD comp[27] NAND3_34/a_2506_982# VDD pfet_03v3 ad=0 pd=0 as=0 ps=0 w=660 l=56
X1271 NAND3_34/a_2506_982# comp[27] VDD VDD pfet_03v3 ad=0 pd=0 as=0 ps=0 w=660 l=56
X1272 NAND3_34/a_2506_982# comp[27] VDD VDD pfet_03v3 ad=0 pd=0 as=0 ps=0 w=660 l=56
X1273 VDD comp[27] NAND3_34/a_2506_982# VDD pfet_03v3 ad=0 pd=0 as=0 ps=0 w=660 l=56
X1274 VDD comp[27] NAND3_34/a_2506_982# VDD pfet_03v3 ad=0 pd=0 as=0 ps=0 w=660 l=56
X1275 VDD NAND3_34/a_2506_982# wl[28] VDD pfet_03v3 ad=0 pd=0 as=0.22308u ps=4.636m w=660 l=56
X1276 wl[28] NAND3_34/a_2506_982# VDD VDD pfet_03v3 ad=0 pd=0 as=0 ps=0 w=660 l=56
X1277 wl[28] NAND3_34/a_2506_982# VDD VDD pfet_03v3 ad=0 pd=0 as=0 ps=0 w=660 l=56
X1278 VDD NAND3_34/a_2506_982# wl[28] VDD pfet_03v3 ad=0 pd=0 as=0 ps=0 w=660 l=56
X1279 VDD NAND3_34/a_2506_982# wl[28] VDD pfet_03v3 ad=0 pd=0 as=0 ps=0 w=660 l=56
X1280 VDD NAND3_34/a_n593_982# NAND3_34/a_2506_982# VDD pfet_03v3 ad=0 pd=0 as=0 ps=0 w=660 l=56
X1281 NAND3_34/a_2506_982# NAND3_34/a_n593_982# VDD VDD pfet_03v3 ad=0 pd=0 as=0 ps=0 w=660 l=56
X1282 NAND3_34/a_2506_982# NAND3_34/a_n593_982# VDD VDD pfet_03v3 ad=0 pd=0 as=0 ps=0 w=660 l=56
X1283 VDD NAND3_34/a_n593_982# NAND3_34/a_2506_982# VDD pfet_03v3 ad=0 pd=0 as=0 ps=0 w=660 l=56
X1284 VDD NAND3_34/a_n593_982# NAND3_34/a_2506_982# VDD pfet_03v3 ad=0 pd=0 as=0 ps=0 w=660 l=56
X1285 NAND3_34/m1_n2243_n1314# comp[28] NAND3_34/m1_n3706_n1374# GND nfet_03v3 ad=0.28245u pd=6.192m as=0.28245u ps=6.192m w=508 l=56
X1286 NAND3_34/m1_n2243_n1314# comp[28] NAND3_34/m1_n3706_n1374# GND nfet_03v3 ad=0 pd=0 as=0 ps=0 w=508 l=56
X1287 NAND3_34/m1_n3706_n1374# comp[28] NAND3_34/m1_n2243_n1314# GND nfet_03v3 ad=0 pd=0 as=0 ps=0 w=508 l=56
X1288 NAND3_34/m1_n3706_n1374# comp[28] NAND3_34/m1_n2243_n1314# GND nfet_03v3 ad=0 pd=0 as=0 ps=0 w=508 l=56
X1289 GND comp[29] NAND3_34/a_n593_982# GND nfet_03v3 ad=0 pd=0 as=0.10566u ps=2.448m w=508 l=56
X1290 GND comp[29] NAND3_34/a_n593_982# GND nfet_03v3 ad=0 pd=0 as=0 ps=0 w=508 l=56
X1291 NAND3_34/a_n593_982# comp[29] GND GND nfet_03v3 ad=0 pd=0 as=0 ps=0 w=508 l=56
X1292 NAND3_34/a_n593_982# comp[29] GND GND nfet_03v3 ad=0 pd=0 as=0 ps=0 w=508 l=56
X1293 GND NAND3_34/a_n593_982# NAND3_34/m1_n2243_n1314# GND nfet_03v3 ad=0 pd=0 as=0 ps=0 w=508 l=56
X1294 GND NAND3_34/a_n593_982# NAND3_34/m1_n2243_n1314# GND nfet_03v3 ad=0 pd=0 as=0 ps=0 w=508 l=56
X1295 NAND3_34/m1_n2243_n1314# NAND3_34/a_n593_982# GND GND nfet_03v3 ad=0 pd=0 as=0 ps=0 w=508 l=56
X1296 NAND3_34/m1_n2243_n1314# NAND3_34/a_n593_982# GND GND nfet_03v3 ad=0 pd=0 as=0 ps=0 w=508 l=56
X1297 NAND3_34/m1_n3706_n1374# comp[27] NAND3_34/a_2506_982# GND nfet_03v3 ad=0 pd=0 as=0.10566u ps=2.448m w=508 l=56
X1298 NAND3_34/m1_n3706_n1374# comp[27] NAND3_34/a_2506_982# GND nfet_03v3 ad=0 pd=0 as=0 ps=0 w=508 l=56
X1299 NAND3_34/a_2506_982# comp[27] NAND3_34/m1_n3706_n1374# GND nfet_03v3 ad=0 pd=0 as=0 ps=0 w=508 l=56
X1300 NAND3_34/a_2506_982# comp[27] NAND3_34/m1_n3706_n1374# GND nfet_03v3 ad=0 pd=0 as=0 ps=0 w=508 l=56
X1301 GND NAND3_34/a_2506_982# wl[28] GND nfet_03v3 ad=0 pd=0 as=0.10566u ps=2.448m w=508 l=56
X1302 GND NAND3_34/a_2506_982# wl[28] GND nfet_03v3 ad=0 pd=0 as=0 ps=0 w=508 l=56
X1303 wl[28] NAND3_34/a_2506_982# GND GND nfet_03v3 ad=0 pd=0 as=0 ps=0 w=508 l=56
X1304 wl[28] NAND3_34/a_2506_982# GND GND nfet_03v3 ad=0 pd=0 as=0 ps=0 w=508 l=56
X1305 VDD comp[18] NAND3_45/a_n593_982# VDD pfet_03v3 ad=0 pd=0 as=0.22308u ps=4.636m w=660 l=56
X1306 NAND3_45/a_n593_982# comp[18] VDD VDD pfet_03v3 ad=0 pd=0 as=0 ps=0 w=660 l=56
X1307 NAND3_45/a_n593_982# comp[18] VDD VDD pfet_03v3 ad=0 pd=0 as=0 ps=0 w=660 l=56
X1308 VDD comp[18] NAND3_45/a_n593_982# VDD pfet_03v3 ad=0 pd=0 as=0 ps=0 w=660 l=56
X1309 VDD comp[18] NAND3_45/a_n593_982# VDD pfet_03v3 ad=0 pd=0 as=0 ps=0 w=660 l=56
X1310 VDD comp[17] NAND3_45/a_2506_982# VDD pfet_03v3 ad=0 pd=0 as=0.66924u ps=0.01391 w=660 l=56
X1311 NAND3_45/a_2506_982# comp[17] VDD VDD pfet_03v3 ad=0 pd=0 as=0 ps=0 w=660 l=56
X1312 NAND3_45/a_2506_982# comp[17] VDD VDD pfet_03v3 ad=0 pd=0 as=0 ps=0 w=660 l=56
X1313 VDD comp[17] NAND3_45/a_2506_982# VDD pfet_03v3 ad=0 pd=0 as=0 ps=0 w=660 l=56
X1314 VDD comp[17] NAND3_45/a_2506_982# VDD pfet_03v3 ad=0 pd=0 as=0 ps=0 w=660 l=56
X1315 VDD comp[16] NAND3_45/a_2506_982# VDD pfet_03v3 ad=0 pd=0 as=0 ps=0 w=660 l=56
X1316 NAND3_45/a_2506_982# comp[16] VDD VDD pfet_03v3 ad=0 pd=0 as=0 ps=0 w=660 l=56
X1317 NAND3_45/a_2506_982# comp[16] VDD VDD pfet_03v3 ad=0 pd=0 as=0 ps=0 w=660 l=56
X1318 VDD comp[16] NAND3_45/a_2506_982# VDD pfet_03v3 ad=0 pd=0 as=0 ps=0 w=660 l=56
X1319 VDD comp[16] NAND3_45/a_2506_982# VDD pfet_03v3 ad=0 pd=0 as=0 ps=0 w=660 l=56
X1320 VDD NAND3_45/a_2506_982# wl[17] VDD pfet_03v3 ad=0 pd=0 as=0.22308u ps=4.636m w=660 l=56
X1321 wl[17] NAND3_45/a_2506_982# VDD VDD pfet_03v3 ad=0 pd=0 as=0 ps=0 w=660 l=56
X1322 wl[17] NAND3_45/a_2506_982# VDD VDD pfet_03v3 ad=0 pd=0 as=0 ps=0 w=660 l=56
X1323 VDD NAND3_45/a_2506_982# wl[17] VDD pfet_03v3 ad=0 pd=0 as=0 ps=0 w=660 l=56
X1324 VDD NAND3_45/a_2506_982# wl[17] VDD pfet_03v3 ad=0 pd=0 as=0 ps=0 w=660 l=56
X1325 VDD NAND3_45/a_n593_982# NAND3_45/a_2506_982# VDD pfet_03v3 ad=0 pd=0 as=0 ps=0 w=660 l=56
X1326 NAND3_45/a_2506_982# NAND3_45/a_n593_982# VDD VDD pfet_03v3 ad=0 pd=0 as=0 ps=0 w=660 l=56
X1327 NAND3_45/a_2506_982# NAND3_45/a_n593_982# VDD VDD pfet_03v3 ad=0 pd=0 as=0 ps=0 w=660 l=56
X1328 VDD NAND3_45/a_n593_982# NAND3_45/a_2506_982# VDD pfet_03v3 ad=0 pd=0 as=0 ps=0 w=660 l=56
X1329 VDD NAND3_45/a_n593_982# NAND3_45/a_2506_982# VDD pfet_03v3 ad=0 pd=0 as=0 ps=0 w=660 l=56
X1330 NAND3_45/m1_n2243_n1314# comp[17] NAND3_45/m1_n3706_n1374# GND nfet_03v3 ad=0.28245u pd=6.192m as=0.28245u ps=6.192m w=508 l=56
X1331 NAND3_45/m1_n2243_n1314# comp[17] NAND3_45/m1_n3706_n1374# GND nfet_03v3 ad=0 pd=0 as=0 ps=0 w=508 l=56
X1332 NAND3_45/m1_n3706_n1374# comp[17] NAND3_45/m1_n2243_n1314# GND nfet_03v3 ad=0 pd=0 as=0 ps=0 w=508 l=56
X1333 NAND3_45/m1_n3706_n1374# comp[17] NAND3_45/m1_n2243_n1314# GND nfet_03v3 ad=0 pd=0 as=0 ps=0 w=508 l=56
X1334 GND comp[18] NAND3_45/a_n593_982# GND nfet_03v3 ad=0 pd=0 as=0.10566u ps=2.448m w=508 l=56
X1335 GND comp[18] NAND3_45/a_n593_982# GND nfet_03v3 ad=0 pd=0 as=0 ps=0 w=508 l=56
X1336 NAND3_45/a_n593_982# comp[18] GND GND nfet_03v3 ad=0 pd=0 as=0 ps=0 w=508 l=56
X1337 NAND3_45/a_n593_982# comp[18] GND GND nfet_03v3 ad=0 pd=0 as=0 ps=0 w=508 l=56
X1338 GND NAND3_45/a_n593_982# NAND3_45/m1_n2243_n1314# GND nfet_03v3 ad=0 pd=0 as=0 ps=0 w=508 l=56
X1339 GND NAND3_45/a_n593_982# NAND3_45/m1_n2243_n1314# GND nfet_03v3 ad=0 pd=0 as=0 ps=0 w=508 l=56
X1340 NAND3_45/m1_n2243_n1314# NAND3_45/a_n593_982# GND GND nfet_03v3 ad=0 pd=0 as=0 ps=0 w=508 l=56
X1341 NAND3_45/m1_n2243_n1314# NAND3_45/a_n593_982# GND GND nfet_03v3 ad=0 pd=0 as=0 ps=0 w=508 l=56
X1342 NAND3_45/m1_n3706_n1374# comp[16] NAND3_45/a_2506_982# GND nfet_03v3 ad=0 pd=0 as=0.10566u ps=2.448m w=508 l=56
X1343 NAND3_45/m1_n3706_n1374# comp[16] NAND3_45/a_2506_982# GND nfet_03v3 ad=0 pd=0 as=0 ps=0 w=508 l=56
X1344 NAND3_45/a_2506_982# comp[16] NAND3_45/m1_n3706_n1374# GND nfet_03v3 ad=0 pd=0 as=0 ps=0 w=508 l=56
X1345 NAND3_45/a_2506_982# comp[16] NAND3_45/m1_n3706_n1374# GND nfet_03v3 ad=0 pd=0 as=0 ps=0 w=508 l=56
X1346 GND NAND3_45/a_2506_982# wl[17] GND nfet_03v3 ad=0 pd=0 as=0.10566u ps=2.448m w=508 l=56
X1347 GND NAND3_45/a_2506_982# wl[17] GND nfet_03v3 ad=0 pd=0 as=0 ps=0 w=508 l=56
X1348 wl[17] NAND3_45/a_2506_982# GND GND nfet_03v3 ad=0 pd=0 as=0 ps=0 w=508 l=56
X1349 wl[17] NAND3_45/a_2506_982# GND GND nfet_03v3 ad=0 pd=0 as=0 ps=0 w=508 l=56
X1350 VDD comp[7] NAND3_56/a_n593_982# VDD pfet_03v3 ad=0 pd=0 as=0.22308u ps=4.636m w=660 l=56
X1351 NAND3_56/a_n593_982# comp[7] VDD VDD pfet_03v3 ad=0 pd=0 as=0 ps=0 w=660 l=56
X1352 NAND3_56/a_n593_982# comp[7] VDD VDD pfet_03v3 ad=0 pd=0 as=0 ps=0 w=660 l=56
X1353 VDD comp[7] NAND3_56/a_n593_982# VDD pfet_03v3 ad=0 pd=0 as=0 ps=0 w=660 l=56
X1354 VDD comp[7] NAND3_56/a_n593_982# VDD pfet_03v3 ad=0 pd=0 as=0 ps=0 w=660 l=56
X1355 VDD comp[6] NAND3_56/a_2506_982# VDD pfet_03v3 ad=0 pd=0 as=0.66924u ps=0.01391 w=660 l=56
X1356 NAND3_56/a_2506_982# comp[6] VDD VDD pfet_03v3 ad=0 pd=0 as=0 ps=0 w=660 l=56
X1357 NAND3_56/a_2506_982# comp[6] VDD VDD pfet_03v3 ad=0 pd=0 as=0 ps=0 w=660 l=56
X1358 VDD comp[6] NAND3_56/a_2506_982# VDD pfet_03v3 ad=0 pd=0 as=0 ps=0 w=660 l=56
X1359 VDD comp[6] NAND3_56/a_2506_982# VDD pfet_03v3 ad=0 pd=0 as=0 ps=0 w=660 l=56
X1360 VDD comp[5] NAND3_56/a_2506_982# VDD pfet_03v3 ad=0 pd=0 as=0 ps=0 w=660 l=56
X1361 NAND3_56/a_2506_982# comp[5] VDD VDD pfet_03v3 ad=0 pd=0 as=0 ps=0 w=660 l=56
X1362 NAND3_56/a_2506_982# comp[5] VDD VDD pfet_03v3 ad=0 pd=0 as=0 ps=0 w=660 l=56
X1363 VDD comp[5] NAND3_56/a_2506_982# VDD pfet_03v3 ad=0 pd=0 as=0 ps=0 w=660 l=56
X1364 VDD comp[5] NAND3_56/a_2506_982# VDD pfet_03v3 ad=0 pd=0 as=0 ps=0 w=660 l=56
X1365 VDD NAND3_56/a_2506_982# wl[6] VDD pfet_03v3 ad=0 pd=0 as=0.22308u ps=4.636m w=660 l=56
X1366 wl[6] NAND3_56/a_2506_982# VDD VDD pfet_03v3 ad=0 pd=0 as=0 ps=0 w=660 l=56
X1367 wl[6] NAND3_56/a_2506_982# VDD VDD pfet_03v3 ad=0 pd=0 as=0 ps=0 w=660 l=56
X1368 VDD NAND3_56/a_2506_982# wl[6] VDD pfet_03v3 ad=0 pd=0 as=0 ps=0 w=660 l=56
X1369 VDD NAND3_56/a_2506_982# wl[6] VDD pfet_03v3 ad=0 pd=0 as=0 ps=0 w=660 l=56
X1370 VDD NAND3_56/a_n593_982# NAND3_56/a_2506_982# VDD pfet_03v3 ad=0 pd=0 as=0 ps=0 w=660 l=56
X1371 NAND3_56/a_2506_982# NAND3_56/a_n593_982# VDD VDD pfet_03v3 ad=0 pd=0 as=0 ps=0 w=660 l=56
X1372 NAND3_56/a_2506_982# NAND3_56/a_n593_982# VDD VDD pfet_03v3 ad=0 pd=0 as=0 ps=0 w=660 l=56
X1373 VDD NAND3_56/a_n593_982# NAND3_56/a_2506_982# VDD pfet_03v3 ad=0 pd=0 as=0 ps=0 w=660 l=56
X1374 VDD NAND3_56/a_n593_982# NAND3_56/a_2506_982# VDD pfet_03v3 ad=0 pd=0 as=0 ps=0 w=660 l=56
X1375 NAND3_56/m1_n2243_n1314# comp[6] NAND3_56/m1_n3706_n1374# GND nfet_03v3 ad=0.28245u pd=6.192m as=0.28245u ps=6.192m w=508 l=56
X1376 NAND3_56/m1_n2243_n1314# comp[6] NAND3_56/m1_n3706_n1374# GND nfet_03v3 ad=0 pd=0 as=0 ps=0 w=508 l=56
X1377 NAND3_56/m1_n3706_n1374# comp[6] NAND3_56/m1_n2243_n1314# GND nfet_03v3 ad=0 pd=0 as=0 ps=0 w=508 l=56
X1378 NAND3_56/m1_n3706_n1374# comp[6] NAND3_56/m1_n2243_n1314# GND nfet_03v3 ad=0 pd=0 as=0 ps=0 w=508 l=56
X1379 GND comp[7] NAND3_56/a_n593_982# GND nfet_03v3 ad=0 pd=0 as=0.10566u ps=2.448m w=508 l=56
X1380 GND comp[7] NAND3_56/a_n593_982# GND nfet_03v3 ad=0 pd=0 as=0 ps=0 w=508 l=56
X1381 NAND3_56/a_n593_982# comp[7] GND GND nfet_03v3 ad=0 pd=0 as=0 ps=0 w=508 l=56
X1382 NAND3_56/a_n593_982# comp[7] GND GND nfet_03v3 ad=0 pd=0 as=0 ps=0 w=508 l=56
X1383 GND NAND3_56/a_n593_982# NAND3_56/m1_n2243_n1314# GND nfet_03v3 ad=0 pd=0 as=0 ps=0 w=508 l=56
X1384 GND NAND3_56/a_n593_982# NAND3_56/m1_n2243_n1314# GND nfet_03v3 ad=0 pd=0 as=0 ps=0 w=508 l=56
X1385 NAND3_56/m1_n2243_n1314# NAND3_56/a_n593_982# GND GND nfet_03v3 ad=0 pd=0 as=0 ps=0 w=508 l=56
X1386 NAND3_56/m1_n2243_n1314# NAND3_56/a_n593_982# GND GND nfet_03v3 ad=0 pd=0 as=0 ps=0 w=508 l=56
X1387 NAND3_56/m1_n3706_n1374# comp[5] NAND3_56/a_2506_982# GND nfet_03v3 ad=0 pd=0 as=0.10566u ps=2.448m w=508 l=56
X1388 NAND3_56/m1_n3706_n1374# comp[5] NAND3_56/a_2506_982# GND nfet_03v3 ad=0 pd=0 as=0 ps=0 w=508 l=56
X1389 NAND3_56/a_2506_982# comp[5] NAND3_56/m1_n3706_n1374# GND nfet_03v3 ad=0 pd=0 as=0 ps=0 w=508 l=56
X1390 NAND3_56/a_2506_982# comp[5] NAND3_56/m1_n3706_n1374# GND nfet_03v3 ad=0 pd=0 as=0 ps=0 w=508 l=56
X1391 GND NAND3_56/a_2506_982# wl[6] GND nfet_03v3 ad=0 pd=0 as=0.10566u ps=2.448m w=508 l=56
X1392 GND NAND3_56/a_2506_982# wl[6] GND nfet_03v3 ad=0 pd=0 as=0 ps=0 w=508 l=56
X1393 wl[6] NAND3_56/a_2506_982# GND GND nfet_03v3 ad=0 pd=0 as=0 ps=0 w=508 l=56
X1394 wl[6] NAND3_56/a_2506_982# GND GND nfet_03v3 ad=0 pd=0 as=0 ps=0 w=508 l=56
X1395 VDD comp[60] NAND3_3/a_n593_982# VDD pfet_03v3 ad=0 pd=0 as=0.22308u ps=4.636m w=660 l=56
X1396 NAND3_3/a_n593_982# comp[60] VDD VDD pfet_03v3 ad=0 pd=0 as=0 ps=0 w=660 l=56
X1397 NAND3_3/a_n593_982# comp[60] VDD VDD pfet_03v3 ad=0 pd=0 as=0 ps=0 w=660 l=56
X1398 VDD comp[60] NAND3_3/a_n593_982# VDD pfet_03v3 ad=0 pd=0 as=0 ps=0 w=660 l=56
X1399 VDD comp[60] NAND3_3/a_n593_982# VDD pfet_03v3 ad=0 pd=0 as=0 ps=0 w=660 l=56
X1400 VDD comp[59] NAND3_3/a_2506_982# VDD pfet_03v3 ad=0 pd=0 as=0.66924u ps=0.01391 w=660 l=56
X1401 NAND3_3/a_2506_982# comp[59] VDD VDD pfet_03v3 ad=0 pd=0 as=0 ps=0 w=660 l=56
X1402 NAND3_3/a_2506_982# comp[59] VDD VDD pfet_03v3 ad=0 pd=0 as=0 ps=0 w=660 l=56
X1403 VDD comp[59] NAND3_3/a_2506_982# VDD pfet_03v3 ad=0 pd=0 as=0 ps=0 w=660 l=56
X1404 VDD comp[59] NAND3_3/a_2506_982# VDD pfet_03v3 ad=0 pd=0 as=0 ps=0 w=660 l=56
X1405 VDD comp[58] NAND3_3/a_2506_982# VDD pfet_03v3 ad=0 pd=0 as=0 ps=0 w=660 l=56
X1406 NAND3_3/a_2506_982# comp[58] VDD VDD pfet_03v3 ad=0 pd=0 as=0 ps=0 w=660 l=56
X1407 NAND3_3/a_2506_982# comp[58] VDD VDD pfet_03v3 ad=0 pd=0 as=0 ps=0 w=660 l=56
X1408 VDD comp[58] NAND3_3/a_2506_982# VDD pfet_03v3 ad=0 pd=0 as=0 ps=0 w=660 l=56
X1409 VDD comp[58] NAND3_3/a_2506_982# VDD pfet_03v3 ad=0 pd=0 as=0 ps=0 w=660 l=56
X1410 VDD NAND3_3/a_2506_982# wl[59] VDD pfet_03v3 ad=0 pd=0 as=0.22308u ps=4.636m w=660 l=56
X1411 wl[59] NAND3_3/a_2506_982# VDD VDD pfet_03v3 ad=0 pd=0 as=0 ps=0 w=660 l=56
X1412 wl[59] NAND3_3/a_2506_982# VDD VDD pfet_03v3 ad=0 pd=0 as=0 ps=0 w=660 l=56
X1413 VDD NAND3_3/a_2506_982# wl[59] VDD pfet_03v3 ad=0 pd=0 as=0 ps=0 w=660 l=56
X1414 VDD NAND3_3/a_2506_982# wl[59] VDD pfet_03v3 ad=0 pd=0 as=0 ps=0 w=660 l=56
X1415 VDD NAND3_3/a_n593_982# NAND3_3/a_2506_982# VDD pfet_03v3 ad=0 pd=0 as=0 ps=0 w=660 l=56
X1416 NAND3_3/a_2506_982# NAND3_3/a_n593_982# VDD VDD pfet_03v3 ad=0 pd=0 as=0 ps=0 w=660 l=56
X1417 NAND3_3/a_2506_982# NAND3_3/a_n593_982# VDD VDD pfet_03v3 ad=0 pd=0 as=0 ps=0 w=660 l=56
X1418 VDD NAND3_3/a_n593_982# NAND3_3/a_2506_982# VDD pfet_03v3 ad=0 pd=0 as=0 ps=0 w=660 l=56
X1419 VDD NAND3_3/a_n593_982# NAND3_3/a_2506_982# VDD pfet_03v3 ad=0 pd=0 as=0 ps=0 w=660 l=56
X1420 NAND3_3/m1_n2243_n1314# comp[59] NAND3_3/m1_n3706_n1374# GND nfet_03v3 ad=0.28245u pd=6.192m as=0.28245u ps=6.192m w=508 l=56
X1421 NAND3_3/m1_n2243_n1314# comp[59] NAND3_3/m1_n3706_n1374# GND nfet_03v3 ad=0 pd=0 as=0 ps=0 w=508 l=56
X1422 NAND3_3/m1_n3706_n1374# comp[59] NAND3_3/m1_n2243_n1314# GND nfet_03v3 ad=0 pd=0 as=0 ps=0 w=508 l=56
X1423 NAND3_3/m1_n3706_n1374# comp[59] NAND3_3/m1_n2243_n1314# GND nfet_03v3 ad=0 pd=0 as=0 ps=0 w=508 l=56
X1424 GND comp[60] NAND3_3/a_n593_982# GND nfet_03v3 ad=0 pd=0 as=0.10566u ps=2.448m w=508 l=56
X1425 GND comp[60] NAND3_3/a_n593_982# GND nfet_03v3 ad=0 pd=0 as=0 ps=0 w=508 l=56
X1426 NAND3_3/a_n593_982# comp[60] GND GND nfet_03v3 ad=0 pd=0 as=0 ps=0 w=508 l=56
X1427 NAND3_3/a_n593_982# comp[60] GND GND nfet_03v3 ad=0 pd=0 as=0 ps=0 w=508 l=56
X1428 GND NAND3_3/a_n593_982# NAND3_3/m1_n2243_n1314# GND nfet_03v3 ad=0 pd=0 as=0 ps=0 w=508 l=56
X1429 GND NAND3_3/a_n593_982# NAND3_3/m1_n2243_n1314# GND nfet_03v3 ad=0 pd=0 as=0 ps=0 w=508 l=56
X1430 NAND3_3/m1_n2243_n1314# NAND3_3/a_n593_982# GND GND nfet_03v3 ad=0 pd=0 as=0 ps=0 w=508 l=56
X1431 NAND3_3/m1_n2243_n1314# NAND3_3/a_n593_982# GND GND nfet_03v3 ad=0 pd=0 as=0 ps=0 w=508 l=56
X1432 NAND3_3/m1_n3706_n1374# comp[58] NAND3_3/a_2506_982# GND nfet_03v3 ad=0 pd=0 as=0.10566u ps=2.448m w=508 l=56
X1433 NAND3_3/m1_n3706_n1374# comp[58] NAND3_3/a_2506_982# GND nfet_03v3 ad=0 pd=0 as=0 ps=0 w=508 l=56
X1434 NAND3_3/a_2506_982# comp[58] NAND3_3/m1_n3706_n1374# GND nfet_03v3 ad=0 pd=0 as=0 ps=0 w=508 l=56
X1435 NAND3_3/a_2506_982# comp[58] NAND3_3/m1_n3706_n1374# GND nfet_03v3 ad=0 pd=0 as=0 ps=0 w=508 l=56
X1436 GND NAND3_3/a_2506_982# wl[59] GND nfet_03v3 ad=0 pd=0 as=0.10566u ps=2.448m w=508 l=56
X1437 GND NAND3_3/a_2506_982# wl[59] GND nfet_03v3 ad=0 pd=0 as=0 ps=0 w=508 l=56
X1438 wl[59] NAND3_3/a_2506_982# GND GND nfet_03v3 ad=0 pd=0 as=0 ps=0 w=508 l=56
X1439 wl[59] NAND3_3/a_2506_982# GND GND nfet_03v3 ad=0 pd=0 as=0 ps=0 w=508 l=56
X1440 VDD comp[50] NAND3_13/a_n593_982# VDD pfet_03v3 ad=0 pd=0 as=0.22308u ps=4.636m w=660 l=56
X1441 NAND3_13/a_n593_982# comp[50] VDD VDD pfet_03v3 ad=0 pd=0 as=0 ps=0 w=660 l=56
X1442 NAND3_13/a_n593_982# comp[50] VDD VDD pfet_03v3 ad=0 pd=0 as=0 ps=0 w=660 l=56
X1443 VDD comp[50] NAND3_13/a_n593_982# VDD pfet_03v3 ad=0 pd=0 as=0 ps=0 w=660 l=56
X1444 VDD comp[50] NAND3_13/a_n593_982# VDD pfet_03v3 ad=0 pd=0 as=0 ps=0 w=660 l=56
X1445 VDD comp[49] NAND3_13/a_2506_982# VDD pfet_03v3 ad=0 pd=0 as=0.66924u ps=0.01391 w=660 l=56
X1446 NAND3_13/a_2506_982# comp[49] VDD VDD pfet_03v3 ad=0 pd=0 as=0 ps=0 w=660 l=56
X1447 NAND3_13/a_2506_982# comp[49] VDD VDD pfet_03v3 ad=0 pd=0 as=0 ps=0 w=660 l=56
X1448 VDD comp[49] NAND3_13/a_2506_982# VDD pfet_03v3 ad=0 pd=0 as=0 ps=0 w=660 l=56
X1449 VDD comp[49] NAND3_13/a_2506_982# VDD pfet_03v3 ad=0 pd=0 as=0 ps=0 w=660 l=56
X1450 VDD comp[48] NAND3_13/a_2506_982# VDD pfet_03v3 ad=0 pd=0 as=0 ps=0 w=660 l=56
X1451 NAND3_13/a_2506_982# comp[48] VDD VDD pfet_03v3 ad=0 pd=0 as=0 ps=0 w=660 l=56
X1452 NAND3_13/a_2506_982# comp[48] VDD VDD pfet_03v3 ad=0 pd=0 as=0 ps=0 w=660 l=56
X1453 VDD comp[48] NAND3_13/a_2506_982# VDD pfet_03v3 ad=0 pd=0 as=0 ps=0 w=660 l=56
X1454 VDD comp[48] NAND3_13/a_2506_982# VDD pfet_03v3 ad=0 pd=0 as=0 ps=0 w=660 l=56
X1455 VDD NAND3_13/a_2506_982# wl[49] VDD pfet_03v3 ad=0 pd=0 as=0.22308u ps=4.636m w=660 l=56
X1456 wl[49] NAND3_13/a_2506_982# VDD VDD pfet_03v3 ad=0 pd=0 as=0 ps=0 w=660 l=56
X1457 wl[49] NAND3_13/a_2506_982# VDD VDD pfet_03v3 ad=0 pd=0 as=0 ps=0 w=660 l=56
X1458 VDD NAND3_13/a_2506_982# wl[49] VDD pfet_03v3 ad=0 pd=0 as=0 ps=0 w=660 l=56
X1459 VDD NAND3_13/a_2506_982# wl[49] VDD pfet_03v3 ad=0 pd=0 as=0 ps=0 w=660 l=56
X1460 VDD NAND3_13/a_n593_982# NAND3_13/a_2506_982# VDD pfet_03v3 ad=0 pd=0 as=0 ps=0 w=660 l=56
X1461 NAND3_13/a_2506_982# NAND3_13/a_n593_982# VDD VDD pfet_03v3 ad=0 pd=0 as=0 ps=0 w=660 l=56
X1462 NAND3_13/a_2506_982# NAND3_13/a_n593_982# VDD VDD pfet_03v3 ad=0 pd=0 as=0 ps=0 w=660 l=56
X1463 VDD NAND3_13/a_n593_982# NAND3_13/a_2506_982# VDD pfet_03v3 ad=0 pd=0 as=0 ps=0 w=660 l=56
X1464 VDD NAND3_13/a_n593_982# NAND3_13/a_2506_982# VDD pfet_03v3 ad=0 pd=0 as=0 ps=0 w=660 l=56
X1465 NAND3_13/m1_n2243_n1314# comp[49] NAND3_13/m1_n3706_n1374# GND nfet_03v3 ad=0.28245u pd=6.192m as=0.28245u ps=6.192m w=508 l=56
X1466 NAND3_13/m1_n2243_n1314# comp[49] NAND3_13/m1_n3706_n1374# GND nfet_03v3 ad=0 pd=0 as=0 ps=0 w=508 l=56
X1467 NAND3_13/m1_n3706_n1374# comp[49] NAND3_13/m1_n2243_n1314# GND nfet_03v3 ad=0 pd=0 as=0 ps=0 w=508 l=56
X1468 NAND3_13/m1_n3706_n1374# comp[49] NAND3_13/m1_n2243_n1314# GND nfet_03v3 ad=0 pd=0 as=0 ps=0 w=508 l=56
X1469 GND comp[50] NAND3_13/a_n593_982# GND nfet_03v3 ad=0 pd=0 as=0.10566u ps=2.448m w=508 l=56
X1470 GND comp[50] NAND3_13/a_n593_982# GND nfet_03v3 ad=0 pd=0 as=0 ps=0 w=508 l=56
X1471 NAND3_13/a_n593_982# comp[50] GND GND nfet_03v3 ad=0 pd=0 as=0 ps=0 w=508 l=56
X1472 NAND3_13/a_n593_982# comp[50] GND GND nfet_03v3 ad=0 pd=0 as=0 ps=0 w=508 l=56
X1473 GND NAND3_13/a_n593_982# NAND3_13/m1_n2243_n1314# GND nfet_03v3 ad=0 pd=0 as=0 ps=0 w=508 l=56
X1474 GND NAND3_13/a_n593_982# NAND3_13/m1_n2243_n1314# GND nfet_03v3 ad=0 pd=0 as=0 ps=0 w=508 l=56
X1475 NAND3_13/m1_n2243_n1314# NAND3_13/a_n593_982# GND GND nfet_03v3 ad=0 pd=0 as=0 ps=0 w=508 l=56
X1476 NAND3_13/m1_n2243_n1314# NAND3_13/a_n593_982# GND GND nfet_03v3 ad=0 pd=0 as=0 ps=0 w=508 l=56
X1477 NAND3_13/m1_n3706_n1374# comp[48] NAND3_13/a_2506_982# GND nfet_03v3 ad=0 pd=0 as=0.10566u ps=2.448m w=508 l=56
X1478 NAND3_13/m1_n3706_n1374# comp[48] NAND3_13/a_2506_982# GND nfet_03v3 ad=0 pd=0 as=0 ps=0 w=508 l=56
X1479 NAND3_13/a_2506_982# comp[48] NAND3_13/m1_n3706_n1374# GND nfet_03v3 ad=0 pd=0 as=0 ps=0 w=508 l=56
X1480 NAND3_13/a_2506_982# comp[48] NAND3_13/m1_n3706_n1374# GND nfet_03v3 ad=0 pd=0 as=0 ps=0 w=508 l=56
X1481 GND NAND3_13/a_2506_982# wl[49] GND nfet_03v3 ad=0 pd=0 as=0.10566u ps=2.448m w=508 l=56
X1482 GND NAND3_13/a_2506_982# wl[49] GND nfet_03v3 ad=0 pd=0 as=0 ps=0 w=508 l=56
X1483 wl[49] NAND3_13/a_2506_982# GND GND nfet_03v3 ad=0 pd=0 as=0 ps=0 w=508 l=56
X1484 wl[49] NAND3_13/a_2506_982# GND GND nfet_03v3 ad=0 pd=0 as=0 ps=0 w=508 l=56
X1485 VDD comp[49] NAND3_14/a_n593_982# VDD pfet_03v3 ad=0 pd=0 as=0.22308u ps=4.636m w=660 l=56
X1486 NAND3_14/a_n593_982# comp[49] VDD VDD pfet_03v3 ad=0 pd=0 as=0 ps=0 w=660 l=56
X1487 NAND3_14/a_n593_982# comp[49] VDD VDD pfet_03v3 ad=0 pd=0 as=0 ps=0 w=660 l=56
X1488 VDD comp[49] NAND3_14/a_n593_982# VDD pfet_03v3 ad=0 pd=0 as=0 ps=0 w=660 l=56
X1489 VDD comp[49] NAND3_14/a_n593_982# VDD pfet_03v3 ad=0 pd=0 as=0 ps=0 w=660 l=56
X1490 VDD comp[48] NAND3_14/a_2506_982# VDD pfet_03v3 ad=0 pd=0 as=0.66924u ps=0.01391 w=660 l=56
X1491 NAND3_14/a_2506_982# comp[48] VDD VDD pfet_03v3 ad=0 pd=0 as=0 ps=0 w=660 l=56
X1492 NAND3_14/a_2506_982# comp[48] VDD VDD pfet_03v3 ad=0 pd=0 as=0 ps=0 w=660 l=56
X1493 VDD comp[48] NAND3_14/a_2506_982# VDD pfet_03v3 ad=0 pd=0 as=0 ps=0 w=660 l=56
X1494 VDD comp[48] NAND3_14/a_2506_982# VDD pfet_03v3 ad=0 pd=0 as=0 ps=0 w=660 l=56
X1495 VDD comp[47] NAND3_14/a_2506_982# VDD pfet_03v3 ad=0 pd=0 as=0 ps=0 w=660 l=56
X1496 NAND3_14/a_2506_982# comp[47] VDD VDD pfet_03v3 ad=0 pd=0 as=0 ps=0 w=660 l=56
X1497 NAND3_14/a_2506_982# comp[47] VDD VDD pfet_03v3 ad=0 pd=0 as=0 ps=0 w=660 l=56
X1498 VDD comp[47] NAND3_14/a_2506_982# VDD pfet_03v3 ad=0 pd=0 as=0 ps=0 w=660 l=56
X1499 VDD comp[47] NAND3_14/a_2506_982# VDD pfet_03v3 ad=0 pd=0 as=0 ps=0 w=660 l=56
X1500 VDD NAND3_14/a_2506_982# wl[48] VDD pfet_03v3 ad=0 pd=0 as=0.22308u ps=4.636m w=660 l=56
X1501 wl[48] NAND3_14/a_2506_982# VDD VDD pfet_03v3 ad=0 pd=0 as=0 ps=0 w=660 l=56
X1502 wl[48] NAND3_14/a_2506_982# VDD VDD pfet_03v3 ad=0 pd=0 as=0 ps=0 w=660 l=56
X1503 VDD NAND3_14/a_2506_982# wl[48] VDD pfet_03v3 ad=0 pd=0 as=0 ps=0 w=660 l=56
X1504 VDD NAND3_14/a_2506_982# wl[48] VDD pfet_03v3 ad=0 pd=0 as=0 ps=0 w=660 l=56
X1505 VDD NAND3_14/a_n593_982# NAND3_14/a_2506_982# VDD pfet_03v3 ad=0 pd=0 as=0 ps=0 w=660 l=56
X1506 NAND3_14/a_2506_982# NAND3_14/a_n593_982# VDD VDD pfet_03v3 ad=0 pd=0 as=0 ps=0 w=660 l=56
X1507 NAND3_14/a_2506_982# NAND3_14/a_n593_982# VDD VDD pfet_03v3 ad=0 pd=0 as=0 ps=0 w=660 l=56
X1508 VDD NAND3_14/a_n593_982# NAND3_14/a_2506_982# VDD pfet_03v3 ad=0 pd=0 as=0 ps=0 w=660 l=56
X1509 VDD NAND3_14/a_n593_982# NAND3_14/a_2506_982# VDD pfet_03v3 ad=0 pd=0 as=0 ps=0 w=660 l=56
X1510 NAND3_14/m1_n2243_n1314# comp[48] NAND3_14/m1_n3706_n1374# GND nfet_03v3 ad=0.28245u pd=6.192m as=0.28245u ps=6.192m w=508 l=56
X1511 NAND3_14/m1_n2243_n1314# comp[48] NAND3_14/m1_n3706_n1374# GND nfet_03v3 ad=0 pd=0 as=0 ps=0 w=508 l=56
X1512 NAND3_14/m1_n3706_n1374# comp[48] NAND3_14/m1_n2243_n1314# GND nfet_03v3 ad=0 pd=0 as=0 ps=0 w=508 l=56
X1513 NAND3_14/m1_n3706_n1374# comp[48] NAND3_14/m1_n2243_n1314# GND nfet_03v3 ad=0 pd=0 as=0 ps=0 w=508 l=56
X1514 GND comp[49] NAND3_14/a_n593_982# GND nfet_03v3 ad=0 pd=0 as=0.10566u ps=2.448m w=508 l=56
X1515 GND comp[49] NAND3_14/a_n593_982# GND nfet_03v3 ad=0 pd=0 as=0 ps=0 w=508 l=56
X1516 NAND3_14/a_n593_982# comp[49] GND GND nfet_03v3 ad=0 pd=0 as=0 ps=0 w=508 l=56
X1517 NAND3_14/a_n593_982# comp[49] GND GND nfet_03v3 ad=0 pd=0 as=0 ps=0 w=508 l=56
X1518 GND NAND3_14/a_n593_982# NAND3_14/m1_n2243_n1314# GND nfet_03v3 ad=0 pd=0 as=0 ps=0 w=508 l=56
X1519 GND NAND3_14/a_n593_982# NAND3_14/m1_n2243_n1314# GND nfet_03v3 ad=0 pd=0 as=0 ps=0 w=508 l=56
X1520 NAND3_14/m1_n2243_n1314# NAND3_14/a_n593_982# GND GND nfet_03v3 ad=0 pd=0 as=0 ps=0 w=508 l=56
X1521 NAND3_14/m1_n2243_n1314# NAND3_14/a_n593_982# GND GND nfet_03v3 ad=0 pd=0 as=0 ps=0 w=508 l=56
X1522 NAND3_14/m1_n3706_n1374# comp[47] NAND3_14/a_2506_982# GND nfet_03v3 ad=0 pd=0 as=0.10566u ps=2.448m w=508 l=56
X1523 NAND3_14/m1_n3706_n1374# comp[47] NAND3_14/a_2506_982# GND nfet_03v3 ad=0 pd=0 as=0 ps=0 w=508 l=56
X1524 NAND3_14/a_2506_982# comp[47] NAND3_14/m1_n3706_n1374# GND nfet_03v3 ad=0 pd=0 as=0 ps=0 w=508 l=56
X1525 NAND3_14/a_2506_982# comp[47] NAND3_14/m1_n3706_n1374# GND nfet_03v3 ad=0 pd=0 as=0 ps=0 w=508 l=56
X1526 GND NAND3_14/a_2506_982# wl[48] GND nfet_03v3 ad=0 pd=0 as=0.10566u ps=2.448m w=508 l=56
X1527 GND NAND3_14/a_2506_982# wl[48] GND nfet_03v3 ad=0 pd=0 as=0 ps=0 w=508 l=56
X1528 wl[48] NAND3_14/a_2506_982# GND GND nfet_03v3 ad=0 pd=0 as=0 ps=0 w=508 l=56
X1529 wl[48] NAND3_14/a_2506_982# GND GND nfet_03v3 ad=0 pd=0 as=0 ps=0 w=508 l=56
X1530 VDD comp[39] NAND3_24/a_n593_982# VDD pfet_03v3 ad=0 pd=0 as=0.22308u ps=4.636m w=660 l=56
X1531 NAND3_24/a_n593_982# comp[39] VDD VDD pfet_03v3 ad=0 pd=0 as=0 ps=0 w=660 l=56
X1532 NAND3_24/a_n593_982# comp[39] VDD VDD pfet_03v3 ad=0 pd=0 as=0 ps=0 w=660 l=56
X1533 VDD comp[39] NAND3_24/a_n593_982# VDD pfet_03v3 ad=0 pd=0 as=0 ps=0 w=660 l=56
X1534 VDD comp[39] NAND3_24/a_n593_982# VDD pfet_03v3 ad=0 pd=0 as=0 ps=0 w=660 l=56
X1535 VDD comp[38] NAND3_24/a_2506_982# VDD pfet_03v3 ad=0 pd=0 as=0.66924u ps=0.01391 w=660 l=56
X1536 NAND3_24/a_2506_982# comp[38] VDD VDD pfet_03v3 ad=0 pd=0 as=0 ps=0 w=660 l=56
X1537 NAND3_24/a_2506_982# comp[38] VDD VDD pfet_03v3 ad=0 pd=0 as=0 ps=0 w=660 l=56
X1538 VDD comp[38] NAND3_24/a_2506_982# VDD pfet_03v3 ad=0 pd=0 as=0 ps=0 w=660 l=56
X1539 VDD comp[38] NAND3_24/a_2506_982# VDD pfet_03v3 ad=0 pd=0 as=0 ps=0 w=660 l=56
X1540 VDD comp[37] NAND3_24/a_2506_982# VDD pfet_03v3 ad=0 pd=0 as=0 ps=0 w=660 l=56
X1541 NAND3_24/a_2506_982# comp[37] VDD VDD pfet_03v3 ad=0 pd=0 as=0 ps=0 w=660 l=56
X1542 NAND3_24/a_2506_982# comp[37] VDD VDD pfet_03v3 ad=0 pd=0 as=0 ps=0 w=660 l=56
X1543 VDD comp[37] NAND3_24/a_2506_982# VDD pfet_03v3 ad=0 pd=0 as=0 ps=0 w=660 l=56
X1544 VDD comp[37] NAND3_24/a_2506_982# VDD pfet_03v3 ad=0 pd=0 as=0 ps=0 w=660 l=56
X1545 VDD NAND3_24/a_2506_982# wl[38] VDD pfet_03v3 ad=0 pd=0 as=0.22308u ps=4.636m w=660 l=56
X1546 wl[38] NAND3_24/a_2506_982# VDD VDD pfet_03v3 ad=0 pd=0 as=0 ps=0 w=660 l=56
X1547 wl[38] NAND3_24/a_2506_982# VDD VDD pfet_03v3 ad=0 pd=0 as=0 ps=0 w=660 l=56
X1548 VDD NAND3_24/a_2506_982# wl[38] VDD pfet_03v3 ad=0 pd=0 as=0 ps=0 w=660 l=56
X1549 VDD NAND3_24/a_2506_982# wl[38] VDD pfet_03v3 ad=0 pd=0 as=0 ps=0 w=660 l=56
X1550 VDD NAND3_24/a_n593_982# NAND3_24/a_2506_982# VDD pfet_03v3 ad=0 pd=0 as=0 ps=0 w=660 l=56
X1551 NAND3_24/a_2506_982# NAND3_24/a_n593_982# VDD VDD pfet_03v3 ad=0 pd=0 as=0 ps=0 w=660 l=56
X1552 NAND3_24/a_2506_982# NAND3_24/a_n593_982# VDD VDD pfet_03v3 ad=0 pd=0 as=0 ps=0 w=660 l=56
X1553 VDD NAND3_24/a_n593_982# NAND3_24/a_2506_982# VDD pfet_03v3 ad=0 pd=0 as=0 ps=0 w=660 l=56
X1554 VDD NAND3_24/a_n593_982# NAND3_24/a_2506_982# VDD pfet_03v3 ad=0 pd=0 as=0 ps=0 w=660 l=56
X1555 NAND3_24/m1_n2243_n1314# comp[38] NAND3_24/m1_n3706_n1374# GND nfet_03v3 ad=0.28245u pd=6.192m as=0.28245u ps=6.192m w=508 l=56
X1556 NAND3_24/m1_n2243_n1314# comp[38] NAND3_24/m1_n3706_n1374# GND nfet_03v3 ad=0 pd=0 as=0 ps=0 w=508 l=56
X1557 NAND3_24/m1_n3706_n1374# comp[38] NAND3_24/m1_n2243_n1314# GND nfet_03v3 ad=0 pd=0 as=0 ps=0 w=508 l=56
X1558 NAND3_24/m1_n3706_n1374# comp[38] NAND3_24/m1_n2243_n1314# GND nfet_03v3 ad=0 pd=0 as=0 ps=0 w=508 l=56
X1559 GND comp[39] NAND3_24/a_n593_982# GND nfet_03v3 ad=0 pd=0 as=0.10566u ps=2.448m w=508 l=56
X1560 GND comp[39] NAND3_24/a_n593_982# GND nfet_03v3 ad=0 pd=0 as=0 ps=0 w=508 l=56
X1561 NAND3_24/a_n593_982# comp[39] GND GND nfet_03v3 ad=0 pd=0 as=0 ps=0 w=508 l=56
X1562 NAND3_24/a_n593_982# comp[39] GND GND nfet_03v3 ad=0 pd=0 as=0 ps=0 w=508 l=56
X1563 GND NAND3_24/a_n593_982# NAND3_24/m1_n2243_n1314# GND nfet_03v3 ad=0 pd=0 as=0 ps=0 w=508 l=56
X1564 GND NAND3_24/a_n593_982# NAND3_24/m1_n2243_n1314# GND nfet_03v3 ad=0 pd=0 as=0 ps=0 w=508 l=56
X1565 NAND3_24/m1_n2243_n1314# NAND3_24/a_n593_982# GND GND nfet_03v3 ad=0 pd=0 as=0 ps=0 w=508 l=56
X1566 NAND3_24/m1_n2243_n1314# NAND3_24/a_n593_982# GND GND nfet_03v3 ad=0 pd=0 as=0 ps=0 w=508 l=56
X1567 NAND3_24/m1_n3706_n1374# comp[37] NAND3_24/a_2506_982# GND nfet_03v3 ad=0 pd=0 as=0.10566u ps=2.448m w=508 l=56
X1568 NAND3_24/m1_n3706_n1374# comp[37] NAND3_24/a_2506_982# GND nfet_03v3 ad=0 pd=0 as=0 ps=0 w=508 l=56
X1569 NAND3_24/a_2506_982# comp[37] NAND3_24/m1_n3706_n1374# GND nfet_03v3 ad=0 pd=0 as=0 ps=0 w=508 l=56
X1570 NAND3_24/a_2506_982# comp[37] NAND3_24/m1_n3706_n1374# GND nfet_03v3 ad=0 pd=0 as=0 ps=0 w=508 l=56
X1571 GND NAND3_24/a_2506_982# wl[38] GND nfet_03v3 ad=0 pd=0 as=0.10566u ps=2.448m w=508 l=56
X1572 GND NAND3_24/a_2506_982# wl[38] GND nfet_03v3 ad=0 pd=0 as=0 ps=0 w=508 l=56
X1573 wl[38] NAND3_24/a_2506_982# GND GND nfet_03v3 ad=0 pd=0 as=0 ps=0 w=508 l=56
X1574 wl[38] NAND3_24/a_2506_982# GND GND nfet_03v3 ad=0 pd=0 as=0 ps=0 w=508 l=56
X1575 VDD comp[38] NAND3_25/a_n593_982# VDD pfet_03v3 ad=0 pd=0 as=0.22308u ps=4.636m w=660 l=56
X1576 NAND3_25/a_n593_982# comp[38] VDD VDD pfet_03v3 ad=0 pd=0 as=0 ps=0 w=660 l=56
X1577 NAND3_25/a_n593_982# comp[38] VDD VDD pfet_03v3 ad=0 pd=0 as=0 ps=0 w=660 l=56
X1578 VDD comp[38] NAND3_25/a_n593_982# VDD pfet_03v3 ad=0 pd=0 as=0 ps=0 w=660 l=56
X1579 VDD comp[38] NAND3_25/a_n593_982# VDD pfet_03v3 ad=0 pd=0 as=0 ps=0 w=660 l=56
X1580 VDD comp[37] NAND3_25/a_2506_982# VDD pfet_03v3 ad=0 pd=0 as=0.66924u ps=0.01391 w=660 l=56
X1581 NAND3_25/a_2506_982# comp[37] VDD VDD pfet_03v3 ad=0 pd=0 as=0 ps=0 w=660 l=56
X1582 NAND3_25/a_2506_982# comp[37] VDD VDD pfet_03v3 ad=0 pd=0 as=0 ps=0 w=660 l=56
X1583 VDD comp[37] NAND3_25/a_2506_982# VDD pfet_03v3 ad=0 pd=0 as=0 ps=0 w=660 l=56
X1584 VDD comp[37] NAND3_25/a_2506_982# VDD pfet_03v3 ad=0 pd=0 as=0 ps=0 w=660 l=56
X1585 VDD comp[36] NAND3_25/a_2506_982# VDD pfet_03v3 ad=0 pd=0 as=0 ps=0 w=660 l=56
X1586 NAND3_25/a_2506_982# comp[36] VDD VDD pfet_03v3 ad=0 pd=0 as=0 ps=0 w=660 l=56
X1587 NAND3_25/a_2506_982# comp[36] VDD VDD pfet_03v3 ad=0 pd=0 as=0 ps=0 w=660 l=56
X1588 VDD comp[36] NAND3_25/a_2506_982# VDD pfet_03v3 ad=0 pd=0 as=0 ps=0 w=660 l=56
X1589 VDD comp[36] NAND3_25/a_2506_982# VDD pfet_03v3 ad=0 pd=0 as=0 ps=0 w=660 l=56
X1590 VDD NAND3_25/a_2506_982# wl[37] VDD pfet_03v3 ad=0 pd=0 as=0.22308u ps=4.636m w=660 l=56
X1591 wl[37] NAND3_25/a_2506_982# VDD VDD pfet_03v3 ad=0 pd=0 as=0 ps=0 w=660 l=56
X1592 wl[37] NAND3_25/a_2506_982# VDD VDD pfet_03v3 ad=0 pd=0 as=0 ps=0 w=660 l=56
X1593 VDD NAND3_25/a_2506_982# wl[37] VDD pfet_03v3 ad=0 pd=0 as=0 ps=0 w=660 l=56
X1594 VDD NAND3_25/a_2506_982# wl[37] VDD pfet_03v3 ad=0 pd=0 as=0 ps=0 w=660 l=56
X1595 VDD NAND3_25/a_n593_982# NAND3_25/a_2506_982# VDD pfet_03v3 ad=0 pd=0 as=0 ps=0 w=660 l=56
X1596 NAND3_25/a_2506_982# NAND3_25/a_n593_982# VDD VDD pfet_03v3 ad=0 pd=0 as=0 ps=0 w=660 l=56
X1597 NAND3_25/a_2506_982# NAND3_25/a_n593_982# VDD VDD pfet_03v3 ad=0 pd=0 as=0 ps=0 w=660 l=56
X1598 VDD NAND3_25/a_n593_982# NAND3_25/a_2506_982# VDD pfet_03v3 ad=0 pd=0 as=0 ps=0 w=660 l=56
X1599 VDD NAND3_25/a_n593_982# NAND3_25/a_2506_982# VDD pfet_03v3 ad=0 pd=0 as=0 ps=0 w=660 l=56
X1600 NAND3_25/m1_n2243_n1314# comp[37] NAND3_25/m1_n3706_n1374# GND nfet_03v3 ad=0.28245u pd=6.192m as=0.28245u ps=6.192m w=508 l=56
X1601 NAND3_25/m1_n2243_n1314# comp[37] NAND3_25/m1_n3706_n1374# GND nfet_03v3 ad=0 pd=0 as=0 ps=0 w=508 l=56
X1602 NAND3_25/m1_n3706_n1374# comp[37] NAND3_25/m1_n2243_n1314# GND nfet_03v3 ad=0 pd=0 as=0 ps=0 w=508 l=56
X1603 NAND3_25/m1_n3706_n1374# comp[37] NAND3_25/m1_n2243_n1314# GND nfet_03v3 ad=0 pd=0 as=0 ps=0 w=508 l=56
X1604 GND comp[38] NAND3_25/a_n593_982# GND nfet_03v3 ad=0 pd=0 as=0.10566u ps=2.448m w=508 l=56
X1605 GND comp[38] NAND3_25/a_n593_982# GND nfet_03v3 ad=0 pd=0 as=0 ps=0 w=508 l=56
X1606 NAND3_25/a_n593_982# comp[38] GND GND nfet_03v3 ad=0 pd=0 as=0 ps=0 w=508 l=56
X1607 NAND3_25/a_n593_982# comp[38] GND GND nfet_03v3 ad=0 pd=0 as=0 ps=0 w=508 l=56
X1608 GND NAND3_25/a_n593_982# NAND3_25/m1_n2243_n1314# GND nfet_03v3 ad=0 pd=0 as=0 ps=0 w=508 l=56
X1609 GND NAND3_25/a_n593_982# NAND3_25/m1_n2243_n1314# GND nfet_03v3 ad=0 pd=0 as=0 ps=0 w=508 l=56
X1610 NAND3_25/m1_n2243_n1314# NAND3_25/a_n593_982# GND GND nfet_03v3 ad=0 pd=0 as=0 ps=0 w=508 l=56
X1611 NAND3_25/m1_n2243_n1314# NAND3_25/a_n593_982# GND GND nfet_03v3 ad=0 pd=0 as=0 ps=0 w=508 l=56
X1612 NAND3_25/m1_n3706_n1374# comp[36] NAND3_25/a_2506_982# GND nfet_03v3 ad=0 pd=0 as=0.10566u ps=2.448m w=508 l=56
X1613 NAND3_25/m1_n3706_n1374# comp[36] NAND3_25/a_2506_982# GND nfet_03v3 ad=0 pd=0 as=0 ps=0 w=508 l=56
X1614 NAND3_25/a_2506_982# comp[36] NAND3_25/m1_n3706_n1374# GND nfet_03v3 ad=0 pd=0 as=0 ps=0 w=508 l=56
X1615 NAND3_25/a_2506_982# comp[36] NAND3_25/m1_n3706_n1374# GND nfet_03v3 ad=0 pd=0 as=0 ps=0 w=508 l=56
X1616 GND NAND3_25/a_2506_982# wl[37] GND nfet_03v3 ad=0 pd=0 as=0.10566u ps=2.448m w=508 l=56
X1617 GND NAND3_25/a_2506_982# wl[37] GND nfet_03v3 ad=0 pd=0 as=0 ps=0 w=508 l=56
X1618 wl[37] NAND3_25/a_2506_982# GND GND nfet_03v3 ad=0 pd=0 as=0 ps=0 w=508 l=56
X1619 wl[37] NAND3_25/a_2506_982# GND GND nfet_03v3 ad=0 pd=0 as=0 ps=0 w=508 l=56
X1620 VDD comp[28] NAND3_35/a_n593_982# VDD pfet_03v3 ad=0 pd=0 as=0.22308u ps=4.636m w=660 l=56
X1621 NAND3_35/a_n593_982# comp[28] VDD VDD pfet_03v3 ad=0 pd=0 as=0 ps=0 w=660 l=56
X1622 NAND3_35/a_n593_982# comp[28] VDD VDD pfet_03v3 ad=0 pd=0 as=0 ps=0 w=660 l=56
X1623 VDD comp[28] NAND3_35/a_n593_982# VDD pfet_03v3 ad=0 pd=0 as=0 ps=0 w=660 l=56
X1624 VDD comp[28] NAND3_35/a_n593_982# VDD pfet_03v3 ad=0 pd=0 as=0 ps=0 w=660 l=56
X1625 VDD comp[27] NAND3_35/a_2506_982# VDD pfet_03v3 ad=0 pd=0 as=0.66924u ps=0.01391 w=660 l=56
X1626 NAND3_35/a_2506_982# comp[27] VDD VDD pfet_03v3 ad=0 pd=0 as=0 ps=0 w=660 l=56
X1627 NAND3_35/a_2506_982# comp[27] VDD VDD pfet_03v3 ad=0 pd=0 as=0 ps=0 w=660 l=56
X1628 VDD comp[27] NAND3_35/a_2506_982# VDD pfet_03v3 ad=0 pd=0 as=0 ps=0 w=660 l=56
X1629 VDD comp[27] NAND3_35/a_2506_982# VDD pfet_03v3 ad=0 pd=0 as=0 ps=0 w=660 l=56
X1630 VDD comp[26] NAND3_35/a_2506_982# VDD pfet_03v3 ad=0 pd=0 as=0 ps=0 w=660 l=56
X1631 NAND3_35/a_2506_982# comp[26] VDD VDD pfet_03v3 ad=0 pd=0 as=0 ps=0 w=660 l=56
X1632 NAND3_35/a_2506_982# comp[26] VDD VDD pfet_03v3 ad=0 pd=0 as=0 ps=0 w=660 l=56
X1633 VDD comp[26] NAND3_35/a_2506_982# VDD pfet_03v3 ad=0 pd=0 as=0 ps=0 w=660 l=56
X1634 VDD comp[26] NAND3_35/a_2506_982# VDD pfet_03v3 ad=0 pd=0 as=0 ps=0 w=660 l=56
X1635 VDD NAND3_35/a_2506_982# wl[27] VDD pfet_03v3 ad=0 pd=0 as=0.22308u ps=4.636m w=660 l=56
X1636 wl[27] NAND3_35/a_2506_982# VDD VDD pfet_03v3 ad=0 pd=0 as=0 ps=0 w=660 l=56
X1637 wl[27] NAND3_35/a_2506_982# VDD VDD pfet_03v3 ad=0 pd=0 as=0 ps=0 w=660 l=56
X1638 VDD NAND3_35/a_2506_982# wl[27] VDD pfet_03v3 ad=0 pd=0 as=0 ps=0 w=660 l=56
X1639 VDD NAND3_35/a_2506_982# wl[27] VDD pfet_03v3 ad=0 pd=0 as=0 ps=0 w=660 l=56
X1640 VDD NAND3_35/a_n593_982# NAND3_35/a_2506_982# VDD pfet_03v3 ad=0 pd=0 as=0 ps=0 w=660 l=56
X1641 NAND3_35/a_2506_982# NAND3_35/a_n593_982# VDD VDD pfet_03v3 ad=0 pd=0 as=0 ps=0 w=660 l=56
X1642 NAND3_35/a_2506_982# NAND3_35/a_n593_982# VDD VDD pfet_03v3 ad=0 pd=0 as=0 ps=0 w=660 l=56
X1643 VDD NAND3_35/a_n593_982# NAND3_35/a_2506_982# VDD pfet_03v3 ad=0 pd=0 as=0 ps=0 w=660 l=56
X1644 VDD NAND3_35/a_n593_982# NAND3_35/a_2506_982# VDD pfet_03v3 ad=0 pd=0 as=0 ps=0 w=660 l=56
X1645 NAND3_35/m1_n2243_n1314# comp[27] NAND3_35/m1_n3706_n1374# GND nfet_03v3 ad=0.28245u pd=6.192m as=0.28245u ps=6.192m w=508 l=56
X1646 NAND3_35/m1_n2243_n1314# comp[27] NAND3_35/m1_n3706_n1374# GND nfet_03v3 ad=0 pd=0 as=0 ps=0 w=508 l=56
X1647 NAND3_35/m1_n3706_n1374# comp[27] NAND3_35/m1_n2243_n1314# GND nfet_03v3 ad=0 pd=0 as=0 ps=0 w=508 l=56
X1648 NAND3_35/m1_n3706_n1374# comp[27] NAND3_35/m1_n2243_n1314# GND nfet_03v3 ad=0 pd=0 as=0 ps=0 w=508 l=56
X1649 GND comp[28] NAND3_35/a_n593_982# GND nfet_03v3 ad=0 pd=0 as=0.10566u ps=2.448m w=508 l=56
X1650 GND comp[28] NAND3_35/a_n593_982# GND nfet_03v3 ad=0 pd=0 as=0 ps=0 w=508 l=56
X1651 NAND3_35/a_n593_982# comp[28] GND GND nfet_03v3 ad=0 pd=0 as=0 ps=0 w=508 l=56
X1652 NAND3_35/a_n593_982# comp[28] GND GND nfet_03v3 ad=0 pd=0 as=0 ps=0 w=508 l=56
X1653 GND NAND3_35/a_n593_982# NAND3_35/m1_n2243_n1314# GND nfet_03v3 ad=0 pd=0 as=0 ps=0 w=508 l=56
X1654 GND NAND3_35/a_n593_982# NAND3_35/m1_n2243_n1314# GND nfet_03v3 ad=0 pd=0 as=0 ps=0 w=508 l=56
X1655 NAND3_35/m1_n2243_n1314# NAND3_35/a_n593_982# GND GND nfet_03v3 ad=0 pd=0 as=0 ps=0 w=508 l=56
X1656 NAND3_35/m1_n2243_n1314# NAND3_35/a_n593_982# GND GND nfet_03v3 ad=0 pd=0 as=0 ps=0 w=508 l=56
X1657 NAND3_35/m1_n3706_n1374# comp[26] NAND3_35/a_2506_982# GND nfet_03v3 ad=0 pd=0 as=0.10566u ps=2.448m w=508 l=56
X1658 NAND3_35/m1_n3706_n1374# comp[26] NAND3_35/a_2506_982# GND nfet_03v3 ad=0 pd=0 as=0 ps=0 w=508 l=56
X1659 NAND3_35/a_2506_982# comp[26] NAND3_35/m1_n3706_n1374# GND nfet_03v3 ad=0 pd=0 as=0 ps=0 w=508 l=56
X1660 NAND3_35/a_2506_982# comp[26] NAND3_35/m1_n3706_n1374# GND nfet_03v3 ad=0 pd=0 as=0 ps=0 w=508 l=56
X1661 GND NAND3_35/a_2506_982# wl[27] GND nfet_03v3 ad=0 pd=0 as=0.10566u ps=2.448m w=508 l=56
X1662 GND NAND3_35/a_2506_982# wl[27] GND nfet_03v3 ad=0 pd=0 as=0 ps=0 w=508 l=56
X1663 wl[27] NAND3_35/a_2506_982# GND GND nfet_03v3 ad=0 pd=0 as=0 ps=0 w=508 l=56
X1664 wl[27] NAND3_35/a_2506_982# GND GND nfet_03v3 ad=0 pd=0 as=0 ps=0 w=508 l=56
X1665 VDD comp[27] NAND3_36/a_n593_982# VDD pfet_03v3 ad=0 pd=0 as=0.22308u ps=4.636m w=660 l=56
X1666 NAND3_36/a_n593_982# comp[27] VDD VDD pfet_03v3 ad=0 pd=0 as=0 ps=0 w=660 l=56
X1667 NAND3_36/a_n593_982# comp[27] VDD VDD pfet_03v3 ad=0 pd=0 as=0 ps=0 w=660 l=56
X1668 VDD comp[27] NAND3_36/a_n593_982# VDD pfet_03v3 ad=0 pd=0 as=0 ps=0 w=660 l=56
X1669 VDD comp[27] NAND3_36/a_n593_982# VDD pfet_03v3 ad=0 pd=0 as=0 ps=0 w=660 l=56
X1670 VDD comp[26] NAND3_36/a_2506_982# VDD pfet_03v3 ad=0 pd=0 as=0.66924u ps=0.01391 w=660 l=56
X1671 NAND3_36/a_2506_982# comp[26] VDD VDD pfet_03v3 ad=0 pd=0 as=0 ps=0 w=660 l=56
X1672 NAND3_36/a_2506_982# comp[26] VDD VDD pfet_03v3 ad=0 pd=0 as=0 ps=0 w=660 l=56
X1673 VDD comp[26] NAND3_36/a_2506_982# VDD pfet_03v3 ad=0 pd=0 as=0 ps=0 w=660 l=56
X1674 VDD comp[26] NAND3_36/a_2506_982# VDD pfet_03v3 ad=0 pd=0 as=0 ps=0 w=660 l=56
X1675 VDD comp[25] NAND3_36/a_2506_982# VDD pfet_03v3 ad=0 pd=0 as=0 ps=0 w=660 l=56
X1676 NAND3_36/a_2506_982# comp[25] VDD VDD pfet_03v3 ad=0 pd=0 as=0 ps=0 w=660 l=56
X1677 NAND3_36/a_2506_982# comp[25] VDD VDD pfet_03v3 ad=0 pd=0 as=0 ps=0 w=660 l=56
X1678 VDD comp[25] NAND3_36/a_2506_982# VDD pfet_03v3 ad=0 pd=0 as=0 ps=0 w=660 l=56
X1679 VDD comp[25] NAND3_36/a_2506_982# VDD pfet_03v3 ad=0 pd=0 as=0 ps=0 w=660 l=56
X1680 VDD NAND3_36/a_2506_982# wl[26] VDD pfet_03v3 ad=0 pd=0 as=0.22308u ps=4.636m w=660 l=56
X1681 wl[26] NAND3_36/a_2506_982# VDD VDD pfet_03v3 ad=0 pd=0 as=0 ps=0 w=660 l=56
X1682 wl[26] NAND3_36/a_2506_982# VDD VDD pfet_03v3 ad=0 pd=0 as=0 ps=0 w=660 l=56
X1683 VDD NAND3_36/a_2506_982# wl[26] VDD pfet_03v3 ad=0 pd=0 as=0 ps=0 w=660 l=56
X1684 VDD NAND3_36/a_2506_982# wl[26] VDD pfet_03v3 ad=0 pd=0 as=0 ps=0 w=660 l=56
X1685 VDD NAND3_36/a_n593_982# NAND3_36/a_2506_982# VDD pfet_03v3 ad=0 pd=0 as=0 ps=0 w=660 l=56
X1686 NAND3_36/a_2506_982# NAND3_36/a_n593_982# VDD VDD pfet_03v3 ad=0 pd=0 as=0 ps=0 w=660 l=56
X1687 NAND3_36/a_2506_982# NAND3_36/a_n593_982# VDD VDD pfet_03v3 ad=0 pd=0 as=0 ps=0 w=660 l=56
X1688 VDD NAND3_36/a_n593_982# NAND3_36/a_2506_982# VDD pfet_03v3 ad=0 pd=0 as=0 ps=0 w=660 l=56
X1689 VDD NAND3_36/a_n593_982# NAND3_36/a_2506_982# VDD pfet_03v3 ad=0 pd=0 as=0 ps=0 w=660 l=56
X1690 NAND3_36/m1_n2243_n1314# comp[26] NAND3_36/m1_n3706_n1374# GND nfet_03v3 ad=0.28245u pd=6.192m as=0.28245u ps=6.192m w=508 l=56
X1691 NAND3_36/m1_n2243_n1314# comp[26] NAND3_36/m1_n3706_n1374# GND nfet_03v3 ad=0 pd=0 as=0 ps=0 w=508 l=56
X1692 NAND3_36/m1_n3706_n1374# comp[26] NAND3_36/m1_n2243_n1314# GND nfet_03v3 ad=0 pd=0 as=0 ps=0 w=508 l=56
X1693 NAND3_36/m1_n3706_n1374# comp[26] NAND3_36/m1_n2243_n1314# GND nfet_03v3 ad=0 pd=0 as=0 ps=0 w=508 l=56
X1694 GND comp[27] NAND3_36/a_n593_982# GND nfet_03v3 ad=0 pd=0 as=0.10566u ps=2.448m w=508 l=56
X1695 GND comp[27] NAND3_36/a_n593_982# GND nfet_03v3 ad=0 pd=0 as=0 ps=0 w=508 l=56
X1696 NAND3_36/a_n593_982# comp[27] GND GND nfet_03v3 ad=0 pd=0 as=0 ps=0 w=508 l=56
X1697 NAND3_36/a_n593_982# comp[27] GND GND nfet_03v3 ad=0 pd=0 as=0 ps=0 w=508 l=56
X1698 GND NAND3_36/a_n593_982# NAND3_36/m1_n2243_n1314# GND nfet_03v3 ad=0 pd=0 as=0 ps=0 w=508 l=56
X1699 GND NAND3_36/a_n593_982# NAND3_36/m1_n2243_n1314# GND nfet_03v3 ad=0 pd=0 as=0 ps=0 w=508 l=56
X1700 NAND3_36/m1_n2243_n1314# NAND3_36/a_n593_982# GND GND nfet_03v3 ad=0 pd=0 as=0 ps=0 w=508 l=56
X1701 NAND3_36/m1_n2243_n1314# NAND3_36/a_n593_982# GND GND nfet_03v3 ad=0 pd=0 as=0 ps=0 w=508 l=56
X1702 NAND3_36/m1_n3706_n1374# comp[25] NAND3_36/a_2506_982# GND nfet_03v3 ad=0 pd=0 as=0.10566u ps=2.448m w=508 l=56
X1703 NAND3_36/m1_n3706_n1374# comp[25] NAND3_36/a_2506_982# GND nfet_03v3 ad=0 pd=0 as=0 ps=0 w=508 l=56
X1704 NAND3_36/a_2506_982# comp[25] NAND3_36/m1_n3706_n1374# GND nfet_03v3 ad=0 pd=0 as=0 ps=0 w=508 l=56
X1705 NAND3_36/a_2506_982# comp[25] NAND3_36/m1_n3706_n1374# GND nfet_03v3 ad=0 pd=0 as=0 ps=0 w=508 l=56
X1706 GND NAND3_36/a_2506_982# wl[26] GND nfet_03v3 ad=0 pd=0 as=0.10566u ps=2.448m w=508 l=56
X1707 GND NAND3_36/a_2506_982# wl[26] GND nfet_03v3 ad=0 pd=0 as=0 ps=0 w=508 l=56
X1708 wl[26] NAND3_36/a_2506_982# GND GND nfet_03v3 ad=0 pd=0 as=0 ps=0 w=508 l=56
X1709 wl[26] NAND3_36/a_2506_982# GND GND nfet_03v3 ad=0 pd=0 as=0 ps=0 w=508 l=56
X1710 VDD comp[17] NAND3_46/a_n593_982# VDD pfet_03v3 ad=0 pd=0 as=0.22308u ps=4.636m w=660 l=56
X1711 NAND3_46/a_n593_982# comp[17] VDD VDD pfet_03v3 ad=0 pd=0 as=0 ps=0 w=660 l=56
X1712 NAND3_46/a_n593_982# comp[17] VDD VDD pfet_03v3 ad=0 pd=0 as=0 ps=0 w=660 l=56
X1713 VDD comp[17] NAND3_46/a_n593_982# VDD pfet_03v3 ad=0 pd=0 as=0 ps=0 w=660 l=56
X1714 VDD comp[17] NAND3_46/a_n593_982# VDD pfet_03v3 ad=0 pd=0 as=0 ps=0 w=660 l=56
X1715 VDD comp[16] NAND3_46/a_2506_982# VDD pfet_03v3 ad=0 pd=0 as=0.66924u ps=0.01391 w=660 l=56
X1716 NAND3_46/a_2506_982# comp[16] VDD VDD pfet_03v3 ad=0 pd=0 as=0 ps=0 w=660 l=56
X1717 NAND3_46/a_2506_982# comp[16] VDD VDD pfet_03v3 ad=0 pd=0 as=0 ps=0 w=660 l=56
X1718 VDD comp[16] NAND3_46/a_2506_982# VDD pfet_03v3 ad=0 pd=0 as=0 ps=0 w=660 l=56
X1719 VDD comp[16] NAND3_46/a_2506_982# VDD pfet_03v3 ad=0 pd=0 as=0 ps=0 w=660 l=56
X1720 VDD comp[15] NAND3_46/a_2506_982# VDD pfet_03v3 ad=0 pd=0 as=0 ps=0 w=660 l=56
X1721 NAND3_46/a_2506_982# comp[15] VDD VDD pfet_03v3 ad=0 pd=0 as=0 ps=0 w=660 l=56
X1722 NAND3_46/a_2506_982# comp[15] VDD VDD pfet_03v3 ad=0 pd=0 as=0 ps=0 w=660 l=56
X1723 VDD comp[15] NAND3_46/a_2506_982# VDD pfet_03v3 ad=0 pd=0 as=0 ps=0 w=660 l=56
X1724 VDD comp[15] NAND3_46/a_2506_982# VDD pfet_03v3 ad=0 pd=0 as=0 ps=0 w=660 l=56
X1725 VDD NAND3_46/a_2506_982# wl[16] VDD pfet_03v3 ad=0 pd=0 as=0.22308u ps=4.636m w=660 l=56
X1726 wl[16] NAND3_46/a_2506_982# VDD VDD pfet_03v3 ad=0 pd=0 as=0 ps=0 w=660 l=56
X1727 wl[16] NAND3_46/a_2506_982# VDD VDD pfet_03v3 ad=0 pd=0 as=0 ps=0 w=660 l=56
X1728 VDD NAND3_46/a_2506_982# wl[16] VDD pfet_03v3 ad=0 pd=0 as=0 ps=0 w=660 l=56
X1729 VDD NAND3_46/a_2506_982# wl[16] VDD pfet_03v3 ad=0 pd=0 as=0 ps=0 w=660 l=56
X1730 VDD NAND3_46/a_n593_982# NAND3_46/a_2506_982# VDD pfet_03v3 ad=0 pd=0 as=0 ps=0 w=660 l=56
X1731 NAND3_46/a_2506_982# NAND3_46/a_n593_982# VDD VDD pfet_03v3 ad=0 pd=0 as=0 ps=0 w=660 l=56
X1732 NAND3_46/a_2506_982# NAND3_46/a_n593_982# VDD VDD pfet_03v3 ad=0 pd=0 as=0 ps=0 w=660 l=56
X1733 VDD NAND3_46/a_n593_982# NAND3_46/a_2506_982# VDD pfet_03v3 ad=0 pd=0 as=0 ps=0 w=660 l=56
X1734 VDD NAND3_46/a_n593_982# NAND3_46/a_2506_982# VDD pfet_03v3 ad=0 pd=0 as=0 ps=0 w=660 l=56
X1735 NAND3_46/m1_n2243_n1314# comp[16] NAND3_46/m1_n3706_n1374# GND nfet_03v3 ad=0.28245u pd=6.192m as=0.28245u ps=6.192m w=508 l=56
X1736 NAND3_46/m1_n2243_n1314# comp[16] NAND3_46/m1_n3706_n1374# GND nfet_03v3 ad=0 pd=0 as=0 ps=0 w=508 l=56
X1737 NAND3_46/m1_n3706_n1374# comp[16] NAND3_46/m1_n2243_n1314# GND nfet_03v3 ad=0 pd=0 as=0 ps=0 w=508 l=56
X1738 NAND3_46/m1_n3706_n1374# comp[16] NAND3_46/m1_n2243_n1314# GND nfet_03v3 ad=0 pd=0 as=0 ps=0 w=508 l=56
X1739 GND comp[17] NAND3_46/a_n593_982# GND nfet_03v3 ad=0 pd=0 as=0.10566u ps=2.448m w=508 l=56
X1740 GND comp[17] NAND3_46/a_n593_982# GND nfet_03v3 ad=0 pd=0 as=0 ps=0 w=508 l=56
X1741 NAND3_46/a_n593_982# comp[17] GND GND nfet_03v3 ad=0 pd=0 as=0 ps=0 w=508 l=56
X1742 NAND3_46/a_n593_982# comp[17] GND GND nfet_03v3 ad=0 pd=0 as=0 ps=0 w=508 l=56
X1743 GND NAND3_46/a_n593_982# NAND3_46/m1_n2243_n1314# GND nfet_03v3 ad=0 pd=0 as=0 ps=0 w=508 l=56
X1744 GND NAND3_46/a_n593_982# NAND3_46/m1_n2243_n1314# GND nfet_03v3 ad=0 pd=0 as=0 ps=0 w=508 l=56
X1745 NAND3_46/m1_n2243_n1314# NAND3_46/a_n593_982# GND GND nfet_03v3 ad=0 pd=0 as=0 ps=0 w=508 l=56
X1746 NAND3_46/m1_n2243_n1314# NAND3_46/a_n593_982# GND GND nfet_03v3 ad=0 pd=0 as=0 ps=0 w=508 l=56
X1747 NAND3_46/m1_n3706_n1374# comp[15] NAND3_46/a_2506_982# GND nfet_03v3 ad=0 pd=0 as=0.10566u ps=2.448m w=508 l=56
X1748 NAND3_46/m1_n3706_n1374# comp[15] NAND3_46/a_2506_982# GND nfet_03v3 ad=0 pd=0 as=0 ps=0 w=508 l=56
X1749 NAND3_46/a_2506_982# comp[15] NAND3_46/m1_n3706_n1374# GND nfet_03v3 ad=0 pd=0 as=0 ps=0 w=508 l=56
X1750 NAND3_46/a_2506_982# comp[15] NAND3_46/m1_n3706_n1374# GND nfet_03v3 ad=0 pd=0 as=0 ps=0 w=508 l=56
X1751 GND NAND3_46/a_2506_982# wl[16] GND nfet_03v3 ad=0 pd=0 as=0.10566u ps=2.448m w=508 l=56
X1752 GND NAND3_46/a_2506_982# wl[16] GND nfet_03v3 ad=0 pd=0 as=0 ps=0 w=508 l=56
X1753 wl[16] NAND3_46/a_2506_982# GND GND nfet_03v3 ad=0 pd=0 as=0 ps=0 w=508 l=56
X1754 wl[16] NAND3_46/a_2506_982# GND GND nfet_03v3 ad=0 pd=0 as=0 ps=0 w=508 l=56
X1755 VDD comp[16] NAND3_47/a_n593_982# VDD pfet_03v3 ad=0 pd=0 as=0.22308u ps=4.636m w=660 l=56
X1756 NAND3_47/a_n593_982# comp[16] VDD VDD pfet_03v3 ad=0 pd=0 as=0 ps=0 w=660 l=56
X1757 NAND3_47/a_n593_982# comp[16] VDD VDD pfet_03v3 ad=0 pd=0 as=0 ps=0 w=660 l=56
X1758 VDD comp[16] NAND3_47/a_n593_982# VDD pfet_03v3 ad=0 pd=0 as=0 ps=0 w=660 l=56
X1759 VDD comp[16] NAND3_47/a_n593_982# VDD pfet_03v3 ad=0 pd=0 as=0 ps=0 w=660 l=56
X1760 VDD comp[15] NAND3_47/a_2506_982# VDD pfet_03v3 ad=0 pd=0 as=0.66924u ps=0.01391 w=660 l=56
X1761 NAND3_47/a_2506_982# comp[15] VDD VDD pfet_03v3 ad=0 pd=0 as=0 ps=0 w=660 l=56
X1762 NAND3_47/a_2506_982# comp[15] VDD VDD pfet_03v3 ad=0 pd=0 as=0 ps=0 w=660 l=56
X1763 VDD comp[15] NAND3_47/a_2506_982# VDD pfet_03v3 ad=0 pd=0 as=0 ps=0 w=660 l=56
X1764 VDD comp[15] NAND3_47/a_2506_982# VDD pfet_03v3 ad=0 pd=0 as=0 ps=0 w=660 l=56
X1765 VDD comp[14] NAND3_47/a_2506_982# VDD pfet_03v3 ad=0 pd=0 as=0 ps=0 w=660 l=56
X1766 NAND3_47/a_2506_982# comp[14] VDD VDD pfet_03v3 ad=0 pd=0 as=0 ps=0 w=660 l=56
X1767 NAND3_47/a_2506_982# comp[14] VDD VDD pfet_03v3 ad=0 pd=0 as=0 ps=0 w=660 l=56
X1768 VDD comp[14] NAND3_47/a_2506_982# VDD pfet_03v3 ad=0 pd=0 as=0 ps=0 w=660 l=56
X1769 VDD comp[14] NAND3_47/a_2506_982# VDD pfet_03v3 ad=0 pd=0 as=0 ps=0 w=660 l=56
X1770 VDD NAND3_47/a_2506_982# wl[15] VDD pfet_03v3 ad=0 pd=0 as=0.22308u ps=4.636m w=660 l=56
X1771 wl[15] NAND3_47/a_2506_982# VDD VDD pfet_03v3 ad=0 pd=0 as=0 ps=0 w=660 l=56
X1772 wl[15] NAND3_47/a_2506_982# VDD VDD pfet_03v3 ad=0 pd=0 as=0 ps=0 w=660 l=56
X1773 VDD NAND3_47/a_2506_982# wl[15] VDD pfet_03v3 ad=0 pd=0 as=0 ps=0 w=660 l=56
X1774 VDD NAND3_47/a_2506_982# wl[15] VDD pfet_03v3 ad=0 pd=0 as=0 ps=0 w=660 l=56
X1775 VDD NAND3_47/a_n593_982# NAND3_47/a_2506_982# VDD pfet_03v3 ad=0 pd=0 as=0 ps=0 w=660 l=56
X1776 NAND3_47/a_2506_982# NAND3_47/a_n593_982# VDD VDD pfet_03v3 ad=0 pd=0 as=0 ps=0 w=660 l=56
X1777 NAND3_47/a_2506_982# NAND3_47/a_n593_982# VDD VDD pfet_03v3 ad=0 pd=0 as=0 ps=0 w=660 l=56
X1778 VDD NAND3_47/a_n593_982# NAND3_47/a_2506_982# VDD pfet_03v3 ad=0 pd=0 as=0 ps=0 w=660 l=56
X1779 VDD NAND3_47/a_n593_982# NAND3_47/a_2506_982# VDD pfet_03v3 ad=0 pd=0 as=0 ps=0 w=660 l=56
X1780 NAND3_47/m1_n2243_n1314# comp[15] NAND3_47/m1_n3706_n1374# GND nfet_03v3 ad=0.28245u pd=6.192m as=0.28245u ps=6.192m w=508 l=56
X1781 NAND3_47/m1_n2243_n1314# comp[15] NAND3_47/m1_n3706_n1374# GND nfet_03v3 ad=0 pd=0 as=0 ps=0 w=508 l=56
X1782 NAND3_47/m1_n3706_n1374# comp[15] NAND3_47/m1_n2243_n1314# GND nfet_03v3 ad=0 pd=0 as=0 ps=0 w=508 l=56
X1783 NAND3_47/m1_n3706_n1374# comp[15] NAND3_47/m1_n2243_n1314# GND nfet_03v3 ad=0 pd=0 as=0 ps=0 w=508 l=56
X1784 GND comp[16] NAND3_47/a_n593_982# GND nfet_03v3 ad=0 pd=0 as=0.10566u ps=2.448m w=508 l=56
X1785 GND comp[16] NAND3_47/a_n593_982# GND nfet_03v3 ad=0 pd=0 as=0 ps=0 w=508 l=56
X1786 NAND3_47/a_n593_982# comp[16] GND GND nfet_03v3 ad=0 pd=0 as=0 ps=0 w=508 l=56
X1787 NAND3_47/a_n593_982# comp[16] GND GND nfet_03v3 ad=0 pd=0 as=0 ps=0 w=508 l=56
X1788 GND NAND3_47/a_n593_982# NAND3_47/m1_n2243_n1314# GND nfet_03v3 ad=0 pd=0 as=0 ps=0 w=508 l=56
X1789 GND NAND3_47/a_n593_982# NAND3_47/m1_n2243_n1314# GND nfet_03v3 ad=0 pd=0 as=0 ps=0 w=508 l=56
X1790 NAND3_47/m1_n2243_n1314# NAND3_47/a_n593_982# GND GND nfet_03v3 ad=0 pd=0 as=0 ps=0 w=508 l=56
X1791 NAND3_47/m1_n2243_n1314# NAND3_47/a_n593_982# GND GND nfet_03v3 ad=0 pd=0 as=0 ps=0 w=508 l=56
X1792 NAND3_47/m1_n3706_n1374# comp[14] NAND3_47/a_2506_982# GND nfet_03v3 ad=0 pd=0 as=0.10566u ps=2.448m w=508 l=56
X1793 NAND3_47/m1_n3706_n1374# comp[14] NAND3_47/a_2506_982# GND nfet_03v3 ad=0 pd=0 as=0 ps=0 w=508 l=56
X1794 NAND3_47/a_2506_982# comp[14] NAND3_47/m1_n3706_n1374# GND nfet_03v3 ad=0 pd=0 as=0 ps=0 w=508 l=56
X1795 NAND3_47/a_2506_982# comp[14] NAND3_47/m1_n3706_n1374# GND nfet_03v3 ad=0 pd=0 as=0 ps=0 w=508 l=56
X1796 GND NAND3_47/a_2506_982# wl[15] GND nfet_03v3 ad=0 pd=0 as=0.10566u ps=2.448m w=508 l=56
X1797 GND NAND3_47/a_2506_982# wl[15] GND nfet_03v3 ad=0 pd=0 as=0 ps=0 w=508 l=56
X1798 wl[15] NAND3_47/a_2506_982# GND GND nfet_03v3 ad=0 pd=0 as=0 ps=0 w=508 l=56
X1799 wl[15] NAND3_47/a_2506_982# GND GND nfet_03v3 ad=0 pd=0 as=0 ps=0 w=508 l=56
X1800 VDD comp[6] NAND3_57/a_n593_982# VDD pfet_03v3 ad=0 pd=0 as=0.22308u ps=4.636m w=660 l=56
X1801 NAND3_57/a_n593_982# comp[6] VDD VDD pfet_03v3 ad=0 pd=0 as=0 ps=0 w=660 l=56
X1802 NAND3_57/a_n593_982# comp[6] VDD VDD pfet_03v3 ad=0 pd=0 as=0 ps=0 w=660 l=56
X1803 VDD comp[6] NAND3_57/a_n593_982# VDD pfet_03v3 ad=0 pd=0 as=0 ps=0 w=660 l=56
X1804 VDD comp[6] NAND3_57/a_n593_982# VDD pfet_03v3 ad=0 pd=0 as=0 ps=0 w=660 l=56
X1805 VDD comp[5] NAND3_57/a_2506_982# VDD pfet_03v3 ad=0 pd=0 as=0.66924u ps=0.01391 w=660 l=56
X1806 NAND3_57/a_2506_982# comp[5] VDD VDD pfet_03v3 ad=0 pd=0 as=0 ps=0 w=660 l=56
X1807 NAND3_57/a_2506_982# comp[5] VDD VDD pfet_03v3 ad=0 pd=0 as=0 ps=0 w=660 l=56
X1808 VDD comp[5] NAND3_57/a_2506_982# VDD pfet_03v3 ad=0 pd=0 as=0 ps=0 w=660 l=56
X1809 VDD comp[5] NAND3_57/a_2506_982# VDD pfet_03v3 ad=0 pd=0 as=0 ps=0 w=660 l=56
X1810 VDD comp[4] NAND3_57/a_2506_982# VDD pfet_03v3 ad=0 pd=0 as=0 ps=0 w=660 l=56
X1811 NAND3_57/a_2506_982# comp[4] VDD VDD pfet_03v3 ad=0 pd=0 as=0 ps=0 w=660 l=56
X1812 NAND3_57/a_2506_982# comp[4] VDD VDD pfet_03v3 ad=0 pd=0 as=0 ps=0 w=660 l=56
X1813 VDD comp[4] NAND3_57/a_2506_982# VDD pfet_03v3 ad=0 pd=0 as=0 ps=0 w=660 l=56
X1814 VDD comp[4] NAND3_57/a_2506_982# VDD pfet_03v3 ad=0 pd=0 as=0 ps=0 w=660 l=56
X1815 VDD NAND3_57/a_2506_982# wl[5] VDD pfet_03v3 ad=0 pd=0 as=0.22308u ps=4.636m w=660 l=56
X1816 wl[5] NAND3_57/a_2506_982# VDD VDD pfet_03v3 ad=0 pd=0 as=0 ps=0 w=660 l=56
X1817 wl[5] NAND3_57/a_2506_982# VDD VDD pfet_03v3 ad=0 pd=0 as=0 ps=0 w=660 l=56
X1818 VDD NAND3_57/a_2506_982# wl[5] VDD pfet_03v3 ad=0 pd=0 as=0 ps=0 w=660 l=56
X1819 VDD NAND3_57/a_2506_982# wl[5] VDD pfet_03v3 ad=0 pd=0 as=0 ps=0 w=660 l=56
X1820 VDD NAND3_57/a_n593_982# NAND3_57/a_2506_982# VDD pfet_03v3 ad=0 pd=0 as=0 ps=0 w=660 l=56
X1821 NAND3_57/a_2506_982# NAND3_57/a_n593_982# VDD VDD pfet_03v3 ad=0 pd=0 as=0 ps=0 w=660 l=56
X1822 NAND3_57/a_2506_982# NAND3_57/a_n593_982# VDD VDD pfet_03v3 ad=0 pd=0 as=0 ps=0 w=660 l=56
X1823 VDD NAND3_57/a_n593_982# NAND3_57/a_2506_982# VDD pfet_03v3 ad=0 pd=0 as=0 ps=0 w=660 l=56
X1824 VDD NAND3_57/a_n593_982# NAND3_57/a_2506_982# VDD pfet_03v3 ad=0 pd=0 as=0 ps=0 w=660 l=56
X1825 NAND3_57/m1_n2243_n1314# comp[5] NAND3_57/m1_n3706_n1374# GND nfet_03v3 ad=0.28245u pd=6.192m as=0.28245u ps=6.192m w=508 l=56
X1826 NAND3_57/m1_n2243_n1314# comp[5] NAND3_57/m1_n3706_n1374# GND nfet_03v3 ad=0 pd=0 as=0 ps=0 w=508 l=56
X1827 NAND3_57/m1_n3706_n1374# comp[5] NAND3_57/m1_n2243_n1314# GND nfet_03v3 ad=0 pd=0 as=0 ps=0 w=508 l=56
X1828 NAND3_57/m1_n3706_n1374# comp[5] NAND3_57/m1_n2243_n1314# GND nfet_03v3 ad=0 pd=0 as=0 ps=0 w=508 l=56
X1829 GND comp[6] NAND3_57/a_n593_982# GND nfet_03v3 ad=0 pd=0 as=0.10566u ps=2.448m w=508 l=56
X1830 GND comp[6] NAND3_57/a_n593_982# GND nfet_03v3 ad=0 pd=0 as=0 ps=0 w=508 l=56
X1831 NAND3_57/a_n593_982# comp[6] GND GND nfet_03v3 ad=0 pd=0 as=0 ps=0 w=508 l=56
X1832 NAND3_57/a_n593_982# comp[6] GND GND nfet_03v3 ad=0 pd=0 as=0 ps=0 w=508 l=56
X1833 GND NAND3_57/a_n593_982# NAND3_57/m1_n2243_n1314# GND nfet_03v3 ad=0 pd=0 as=0 ps=0 w=508 l=56
X1834 GND NAND3_57/a_n593_982# NAND3_57/m1_n2243_n1314# GND nfet_03v3 ad=0 pd=0 as=0 ps=0 w=508 l=56
X1835 NAND3_57/m1_n2243_n1314# NAND3_57/a_n593_982# GND GND nfet_03v3 ad=0 pd=0 as=0 ps=0 w=508 l=56
X1836 NAND3_57/m1_n2243_n1314# NAND3_57/a_n593_982# GND GND nfet_03v3 ad=0 pd=0 as=0 ps=0 w=508 l=56
X1837 NAND3_57/m1_n3706_n1374# comp[4] NAND3_57/a_2506_982# GND nfet_03v3 ad=0 pd=0 as=0.10566u ps=2.448m w=508 l=56
X1838 NAND3_57/m1_n3706_n1374# comp[4] NAND3_57/a_2506_982# GND nfet_03v3 ad=0 pd=0 as=0 ps=0 w=508 l=56
X1839 NAND3_57/a_2506_982# comp[4] NAND3_57/m1_n3706_n1374# GND nfet_03v3 ad=0 pd=0 as=0 ps=0 w=508 l=56
X1840 NAND3_57/a_2506_982# comp[4] NAND3_57/m1_n3706_n1374# GND nfet_03v3 ad=0 pd=0 as=0 ps=0 w=508 l=56
X1841 GND NAND3_57/a_2506_982# wl[5] GND nfet_03v3 ad=0 pd=0 as=0.10566u ps=2.448m w=508 l=56
X1842 GND NAND3_57/a_2506_982# wl[5] GND nfet_03v3 ad=0 pd=0 as=0 ps=0 w=508 l=56
X1843 wl[5] NAND3_57/a_2506_982# GND GND nfet_03v3 ad=0 pd=0 as=0 ps=0 w=508 l=56
X1844 wl[5] NAND3_57/a_2506_982# GND GND nfet_03v3 ad=0 pd=0 as=0 ps=0 w=508 l=56
X1845 VDD comp[5] NAND3_58/a_n593_982# VDD pfet_03v3 ad=0 pd=0 as=0.22308u ps=4.636m w=660 l=56
X1846 NAND3_58/a_n593_982# comp[5] VDD VDD pfet_03v3 ad=0 pd=0 as=0 ps=0 w=660 l=56
X1847 NAND3_58/a_n593_982# comp[5] VDD VDD pfet_03v3 ad=0 pd=0 as=0 ps=0 w=660 l=56
X1848 VDD comp[5] NAND3_58/a_n593_982# VDD pfet_03v3 ad=0 pd=0 as=0 ps=0 w=660 l=56
X1849 VDD comp[5] NAND3_58/a_n593_982# VDD pfet_03v3 ad=0 pd=0 as=0 ps=0 w=660 l=56
X1850 VDD comp[4] NAND3_58/a_2506_982# VDD pfet_03v3 ad=0 pd=0 as=0.66924u ps=0.01391 w=660 l=56
X1851 NAND3_58/a_2506_982# comp[4] VDD VDD pfet_03v3 ad=0 pd=0 as=0 ps=0 w=660 l=56
X1852 NAND3_58/a_2506_982# comp[4] VDD VDD pfet_03v3 ad=0 pd=0 as=0 ps=0 w=660 l=56
X1853 VDD comp[4] NAND3_58/a_2506_982# VDD pfet_03v3 ad=0 pd=0 as=0 ps=0 w=660 l=56
X1854 VDD comp[4] NAND3_58/a_2506_982# VDD pfet_03v3 ad=0 pd=0 as=0 ps=0 w=660 l=56
X1855 VDD comp[3] NAND3_58/a_2506_982# VDD pfet_03v3 ad=0 pd=0 as=0 ps=0 w=660 l=56
X1856 NAND3_58/a_2506_982# comp[3] VDD VDD pfet_03v3 ad=0 pd=0 as=0 ps=0 w=660 l=56
X1857 NAND3_58/a_2506_982# comp[3] VDD VDD pfet_03v3 ad=0 pd=0 as=0 ps=0 w=660 l=56
X1858 VDD comp[3] NAND3_58/a_2506_982# VDD pfet_03v3 ad=0 pd=0 as=0 ps=0 w=660 l=56
X1859 VDD comp[3] NAND3_58/a_2506_982# VDD pfet_03v3 ad=0 pd=0 as=0 ps=0 w=660 l=56
X1860 VDD NAND3_58/a_2506_982# wl[4] VDD pfet_03v3 ad=0 pd=0 as=0.22308u ps=4.636m w=660 l=56
X1861 wl[4] NAND3_58/a_2506_982# VDD VDD pfet_03v3 ad=0 pd=0 as=0 ps=0 w=660 l=56
X1862 wl[4] NAND3_58/a_2506_982# VDD VDD pfet_03v3 ad=0 pd=0 as=0 ps=0 w=660 l=56
X1863 VDD NAND3_58/a_2506_982# wl[4] VDD pfet_03v3 ad=0 pd=0 as=0 ps=0 w=660 l=56
X1864 VDD NAND3_58/a_2506_982# wl[4] VDD pfet_03v3 ad=0 pd=0 as=0 ps=0 w=660 l=56
X1865 VDD NAND3_58/a_n593_982# NAND3_58/a_2506_982# VDD pfet_03v3 ad=0 pd=0 as=0 ps=0 w=660 l=56
X1866 NAND3_58/a_2506_982# NAND3_58/a_n593_982# VDD VDD pfet_03v3 ad=0 pd=0 as=0 ps=0 w=660 l=56
X1867 NAND3_58/a_2506_982# NAND3_58/a_n593_982# VDD VDD pfet_03v3 ad=0 pd=0 as=0 ps=0 w=660 l=56
X1868 VDD NAND3_58/a_n593_982# NAND3_58/a_2506_982# VDD pfet_03v3 ad=0 pd=0 as=0 ps=0 w=660 l=56
X1869 VDD NAND3_58/a_n593_982# NAND3_58/a_2506_982# VDD pfet_03v3 ad=0 pd=0 as=0 ps=0 w=660 l=56
X1870 NAND3_58/m1_n2243_n1314# comp[4] NAND3_58/m1_n3706_n1374# GND nfet_03v3 ad=0.28245u pd=6.192m as=0.28245u ps=6.192m w=508 l=56
X1871 NAND3_58/m1_n2243_n1314# comp[4] NAND3_58/m1_n3706_n1374# GND nfet_03v3 ad=0 pd=0 as=0 ps=0 w=508 l=56
X1872 NAND3_58/m1_n3706_n1374# comp[4] NAND3_58/m1_n2243_n1314# GND nfet_03v3 ad=0 pd=0 as=0 ps=0 w=508 l=56
X1873 NAND3_58/m1_n3706_n1374# comp[4] NAND3_58/m1_n2243_n1314# GND nfet_03v3 ad=0 pd=0 as=0 ps=0 w=508 l=56
X1874 GND comp[5] NAND3_58/a_n593_982# GND nfet_03v3 ad=0 pd=0 as=0.10566u ps=2.448m w=508 l=56
X1875 GND comp[5] NAND3_58/a_n593_982# GND nfet_03v3 ad=0 pd=0 as=0 ps=0 w=508 l=56
X1876 NAND3_58/a_n593_982# comp[5] GND GND nfet_03v3 ad=0 pd=0 as=0 ps=0 w=508 l=56
X1877 NAND3_58/a_n593_982# comp[5] GND GND nfet_03v3 ad=0 pd=0 as=0 ps=0 w=508 l=56
X1878 GND NAND3_58/a_n593_982# NAND3_58/m1_n2243_n1314# GND nfet_03v3 ad=0 pd=0 as=0 ps=0 w=508 l=56
X1879 GND NAND3_58/a_n593_982# NAND3_58/m1_n2243_n1314# GND nfet_03v3 ad=0 pd=0 as=0 ps=0 w=508 l=56
X1880 NAND3_58/m1_n2243_n1314# NAND3_58/a_n593_982# GND GND nfet_03v3 ad=0 pd=0 as=0 ps=0 w=508 l=56
X1881 NAND3_58/m1_n2243_n1314# NAND3_58/a_n593_982# GND GND nfet_03v3 ad=0 pd=0 as=0 ps=0 w=508 l=56
X1882 NAND3_58/m1_n3706_n1374# comp[3] NAND3_58/a_2506_982# GND nfet_03v3 ad=0 pd=0 as=0.10566u ps=2.448m w=508 l=56
X1883 NAND3_58/m1_n3706_n1374# comp[3] NAND3_58/a_2506_982# GND nfet_03v3 ad=0 pd=0 as=0 ps=0 w=508 l=56
X1884 NAND3_58/a_2506_982# comp[3] NAND3_58/m1_n3706_n1374# GND nfet_03v3 ad=0 pd=0 as=0 ps=0 w=508 l=56
X1885 NAND3_58/a_2506_982# comp[3] NAND3_58/m1_n3706_n1374# GND nfet_03v3 ad=0 pd=0 as=0 ps=0 w=508 l=56
X1886 GND NAND3_58/a_2506_982# wl[4] GND nfet_03v3 ad=0 pd=0 as=0.10566u ps=2.448m w=508 l=56
X1887 GND NAND3_58/a_2506_982# wl[4] GND nfet_03v3 ad=0 pd=0 as=0 ps=0 w=508 l=56
X1888 wl[4] NAND3_58/a_2506_982# GND GND nfet_03v3 ad=0 pd=0 as=0 ps=0 w=508 l=56
X1889 wl[4] NAND3_58/a_2506_982# GND GND nfet_03v3 ad=0 pd=0 as=0 ps=0 w=508 l=56
X1890 VDD comp[59] NAND3_4/a_n593_982# VDD pfet_03v3 ad=0 pd=0 as=0.22308u ps=4.636m w=660 l=56
X1891 NAND3_4/a_n593_982# comp[59] VDD VDD pfet_03v3 ad=0 pd=0 as=0 ps=0 w=660 l=56
X1892 NAND3_4/a_n593_982# comp[59] VDD VDD pfet_03v3 ad=0 pd=0 as=0 ps=0 w=660 l=56
X1893 VDD comp[59] NAND3_4/a_n593_982# VDD pfet_03v3 ad=0 pd=0 as=0 ps=0 w=660 l=56
X1894 VDD comp[59] NAND3_4/a_n593_982# VDD pfet_03v3 ad=0 pd=0 as=0 ps=0 w=660 l=56
X1895 VDD comp[58] NAND3_4/a_2506_982# VDD pfet_03v3 ad=0 pd=0 as=0.66924u ps=0.01391 w=660 l=56
X1896 NAND3_4/a_2506_982# comp[58] VDD VDD pfet_03v3 ad=0 pd=0 as=0 ps=0 w=660 l=56
X1897 NAND3_4/a_2506_982# comp[58] VDD VDD pfet_03v3 ad=0 pd=0 as=0 ps=0 w=660 l=56
X1898 VDD comp[58] NAND3_4/a_2506_982# VDD pfet_03v3 ad=0 pd=0 as=0 ps=0 w=660 l=56
X1899 VDD comp[58] NAND3_4/a_2506_982# VDD pfet_03v3 ad=0 pd=0 as=0 ps=0 w=660 l=56
X1900 VDD comp[57] NAND3_4/a_2506_982# VDD pfet_03v3 ad=0 pd=0 as=0 ps=0 w=660 l=56
X1901 NAND3_4/a_2506_982# comp[57] VDD VDD pfet_03v3 ad=0 pd=0 as=0 ps=0 w=660 l=56
X1902 NAND3_4/a_2506_982# comp[57] VDD VDD pfet_03v3 ad=0 pd=0 as=0 ps=0 w=660 l=56
X1903 VDD comp[57] NAND3_4/a_2506_982# VDD pfet_03v3 ad=0 pd=0 as=0 ps=0 w=660 l=56
X1904 VDD comp[57] NAND3_4/a_2506_982# VDD pfet_03v3 ad=0 pd=0 as=0 ps=0 w=660 l=56
X1905 VDD NAND3_4/a_2506_982# wl[58] VDD pfet_03v3 ad=0 pd=0 as=0.22308u ps=4.636m w=660 l=56
X1906 wl[58] NAND3_4/a_2506_982# VDD VDD pfet_03v3 ad=0 pd=0 as=0 ps=0 w=660 l=56
X1907 wl[58] NAND3_4/a_2506_982# VDD VDD pfet_03v3 ad=0 pd=0 as=0 ps=0 w=660 l=56
X1908 VDD NAND3_4/a_2506_982# wl[58] VDD pfet_03v3 ad=0 pd=0 as=0 ps=0 w=660 l=56
X1909 VDD NAND3_4/a_2506_982# wl[58] VDD pfet_03v3 ad=0 pd=0 as=0 ps=0 w=660 l=56
X1910 VDD NAND3_4/a_n593_982# NAND3_4/a_2506_982# VDD pfet_03v3 ad=0 pd=0 as=0 ps=0 w=660 l=56
X1911 NAND3_4/a_2506_982# NAND3_4/a_n593_982# VDD VDD pfet_03v3 ad=0 pd=0 as=0 ps=0 w=660 l=56
X1912 NAND3_4/a_2506_982# NAND3_4/a_n593_982# VDD VDD pfet_03v3 ad=0 pd=0 as=0 ps=0 w=660 l=56
X1913 VDD NAND3_4/a_n593_982# NAND3_4/a_2506_982# VDD pfet_03v3 ad=0 pd=0 as=0 ps=0 w=660 l=56
X1914 VDD NAND3_4/a_n593_982# NAND3_4/a_2506_982# VDD pfet_03v3 ad=0 pd=0 as=0 ps=0 w=660 l=56
X1915 NAND3_4/m1_n2243_n1314# comp[58] NAND3_4/m1_n3706_n1374# GND nfet_03v3 ad=0.28245u pd=6.192m as=0.28245u ps=6.192m w=508 l=56
X1916 NAND3_4/m1_n2243_n1314# comp[58] NAND3_4/m1_n3706_n1374# GND nfet_03v3 ad=0 pd=0 as=0 ps=0 w=508 l=56
X1917 NAND3_4/m1_n3706_n1374# comp[58] NAND3_4/m1_n2243_n1314# GND nfet_03v3 ad=0 pd=0 as=0 ps=0 w=508 l=56
X1918 NAND3_4/m1_n3706_n1374# comp[58] NAND3_4/m1_n2243_n1314# GND nfet_03v3 ad=0 pd=0 as=0 ps=0 w=508 l=56
X1919 GND comp[59] NAND3_4/a_n593_982# GND nfet_03v3 ad=0 pd=0 as=0.10566u ps=2.448m w=508 l=56
X1920 GND comp[59] NAND3_4/a_n593_982# GND nfet_03v3 ad=0 pd=0 as=0 ps=0 w=508 l=56
X1921 NAND3_4/a_n593_982# comp[59] GND GND nfet_03v3 ad=0 pd=0 as=0 ps=0 w=508 l=56
X1922 NAND3_4/a_n593_982# comp[59] GND GND nfet_03v3 ad=0 pd=0 as=0 ps=0 w=508 l=56
X1923 GND NAND3_4/a_n593_982# NAND3_4/m1_n2243_n1314# GND nfet_03v3 ad=0 pd=0 as=0 ps=0 w=508 l=56
X1924 GND NAND3_4/a_n593_982# NAND3_4/m1_n2243_n1314# GND nfet_03v3 ad=0 pd=0 as=0 ps=0 w=508 l=56
X1925 NAND3_4/m1_n2243_n1314# NAND3_4/a_n593_982# GND GND nfet_03v3 ad=0 pd=0 as=0 ps=0 w=508 l=56
X1926 NAND3_4/m1_n2243_n1314# NAND3_4/a_n593_982# GND GND nfet_03v3 ad=0 pd=0 as=0 ps=0 w=508 l=56
X1927 NAND3_4/m1_n3706_n1374# comp[57] NAND3_4/a_2506_982# GND nfet_03v3 ad=0 pd=0 as=0.10566u ps=2.448m w=508 l=56
X1928 NAND3_4/m1_n3706_n1374# comp[57] NAND3_4/a_2506_982# GND nfet_03v3 ad=0 pd=0 as=0 ps=0 w=508 l=56
X1929 NAND3_4/a_2506_982# comp[57] NAND3_4/m1_n3706_n1374# GND nfet_03v3 ad=0 pd=0 as=0 ps=0 w=508 l=56
X1930 NAND3_4/a_2506_982# comp[57] NAND3_4/m1_n3706_n1374# GND nfet_03v3 ad=0 pd=0 as=0 ps=0 w=508 l=56
X1931 GND NAND3_4/a_2506_982# wl[58] GND nfet_03v3 ad=0 pd=0 as=0.10566u ps=2.448m w=508 l=56
X1932 GND NAND3_4/a_2506_982# wl[58] GND nfet_03v3 ad=0 pd=0 as=0 ps=0 w=508 l=56
X1933 wl[58] NAND3_4/a_2506_982# GND GND nfet_03v3 ad=0 pd=0 as=0 ps=0 w=508 l=56
X1934 wl[58] NAND3_4/a_2506_982# GND GND nfet_03v3 ad=0 pd=0 as=0 ps=0 w=508 l=56
X1935 VDD comp[48] NAND3_15/a_n593_982# VDD pfet_03v3 ad=0 pd=0 as=0.22308u ps=4.636m w=660 l=56
X1936 NAND3_15/a_n593_982# comp[48] VDD VDD pfet_03v3 ad=0 pd=0 as=0 ps=0 w=660 l=56
X1937 NAND3_15/a_n593_982# comp[48] VDD VDD pfet_03v3 ad=0 pd=0 as=0 ps=0 w=660 l=56
X1938 VDD comp[48] NAND3_15/a_n593_982# VDD pfet_03v3 ad=0 pd=0 as=0 ps=0 w=660 l=56
X1939 VDD comp[48] NAND3_15/a_n593_982# VDD pfet_03v3 ad=0 pd=0 as=0 ps=0 w=660 l=56
X1940 VDD comp[47] NAND3_15/a_2506_982# VDD pfet_03v3 ad=0 pd=0 as=0.66924u ps=0.01391 w=660 l=56
X1941 NAND3_15/a_2506_982# comp[47] VDD VDD pfet_03v3 ad=0 pd=0 as=0 ps=0 w=660 l=56
X1942 NAND3_15/a_2506_982# comp[47] VDD VDD pfet_03v3 ad=0 pd=0 as=0 ps=0 w=660 l=56
X1943 VDD comp[47] NAND3_15/a_2506_982# VDD pfet_03v3 ad=0 pd=0 as=0 ps=0 w=660 l=56
X1944 VDD comp[47] NAND3_15/a_2506_982# VDD pfet_03v3 ad=0 pd=0 as=0 ps=0 w=660 l=56
X1945 VDD comp[46] NAND3_15/a_2506_982# VDD pfet_03v3 ad=0 pd=0 as=0 ps=0 w=660 l=56
X1946 NAND3_15/a_2506_982# comp[46] VDD VDD pfet_03v3 ad=0 pd=0 as=0 ps=0 w=660 l=56
X1947 NAND3_15/a_2506_982# comp[46] VDD VDD pfet_03v3 ad=0 pd=0 as=0 ps=0 w=660 l=56
X1948 VDD comp[46] NAND3_15/a_2506_982# VDD pfet_03v3 ad=0 pd=0 as=0 ps=0 w=660 l=56
X1949 VDD comp[46] NAND3_15/a_2506_982# VDD pfet_03v3 ad=0 pd=0 as=0 ps=0 w=660 l=56
X1950 VDD NAND3_15/a_2506_982# wl[47] VDD pfet_03v3 ad=0 pd=0 as=0.22308u ps=4.636m w=660 l=56
X1951 wl[47] NAND3_15/a_2506_982# VDD VDD pfet_03v3 ad=0 pd=0 as=0 ps=0 w=660 l=56
X1952 wl[47] NAND3_15/a_2506_982# VDD VDD pfet_03v3 ad=0 pd=0 as=0 ps=0 w=660 l=56
X1953 VDD NAND3_15/a_2506_982# wl[47] VDD pfet_03v3 ad=0 pd=0 as=0 ps=0 w=660 l=56
X1954 VDD NAND3_15/a_2506_982# wl[47] VDD pfet_03v3 ad=0 pd=0 as=0 ps=0 w=660 l=56
X1955 VDD NAND3_15/a_n593_982# NAND3_15/a_2506_982# VDD pfet_03v3 ad=0 pd=0 as=0 ps=0 w=660 l=56
X1956 NAND3_15/a_2506_982# NAND3_15/a_n593_982# VDD VDD pfet_03v3 ad=0 pd=0 as=0 ps=0 w=660 l=56
X1957 NAND3_15/a_2506_982# NAND3_15/a_n593_982# VDD VDD pfet_03v3 ad=0 pd=0 as=0 ps=0 w=660 l=56
X1958 VDD NAND3_15/a_n593_982# NAND3_15/a_2506_982# VDD pfet_03v3 ad=0 pd=0 as=0 ps=0 w=660 l=56
X1959 VDD NAND3_15/a_n593_982# NAND3_15/a_2506_982# VDD pfet_03v3 ad=0 pd=0 as=0 ps=0 w=660 l=56
X1960 NAND3_15/m1_n2243_n1314# comp[47] NAND3_15/m1_n3706_n1374# GND nfet_03v3 ad=0.28245u pd=6.192m as=0.28245u ps=6.192m w=508 l=56
X1961 NAND3_15/m1_n2243_n1314# comp[47] NAND3_15/m1_n3706_n1374# GND nfet_03v3 ad=0 pd=0 as=0 ps=0 w=508 l=56
X1962 NAND3_15/m1_n3706_n1374# comp[47] NAND3_15/m1_n2243_n1314# GND nfet_03v3 ad=0 pd=0 as=0 ps=0 w=508 l=56
X1963 NAND3_15/m1_n3706_n1374# comp[47] NAND3_15/m1_n2243_n1314# GND nfet_03v3 ad=0 pd=0 as=0 ps=0 w=508 l=56
X1964 GND comp[48] NAND3_15/a_n593_982# GND nfet_03v3 ad=0 pd=0 as=0.10566u ps=2.448m w=508 l=56
X1965 GND comp[48] NAND3_15/a_n593_982# GND nfet_03v3 ad=0 pd=0 as=0 ps=0 w=508 l=56
X1966 NAND3_15/a_n593_982# comp[48] GND GND nfet_03v3 ad=0 pd=0 as=0 ps=0 w=508 l=56
X1967 NAND3_15/a_n593_982# comp[48] GND GND nfet_03v3 ad=0 pd=0 as=0 ps=0 w=508 l=56
X1968 GND NAND3_15/a_n593_982# NAND3_15/m1_n2243_n1314# GND nfet_03v3 ad=0 pd=0 as=0 ps=0 w=508 l=56
X1969 GND NAND3_15/a_n593_982# NAND3_15/m1_n2243_n1314# GND nfet_03v3 ad=0 pd=0 as=0 ps=0 w=508 l=56
X1970 NAND3_15/m1_n2243_n1314# NAND3_15/a_n593_982# GND GND nfet_03v3 ad=0 pd=0 as=0 ps=0 w=508 l=56
X1971 NAND3_15/m1_n2243_n1314# NAND3_15/a_n593_982# GND GND nfet_03v3 ad=0 pd=0 as=0 ps=0 w=508 l=56
X1972 NAND3_15/m1_n3706_n1374# comp[46] NAND3_15/a_2506_982# GND nfet_03v3 ad=0 pd=0 as=0.10566u ps=2.448m w=508 l=56
X1973 NAND3_15/m1_n3706_n1374# comp[46] NAND3_15/a_2506_982# GND nfet_03v3 ad=0 pd=0 as=0 ps=0 w=508 l=56
X1974 NAND3_15/a_2506_982# comp[46] NAND3_15/m1_n3706_n1374# GND nfet_03v3 ad=0 pd=0 as=0 ps=0 w=508 l=56
X1975 NAND3_15/a_2506_982# comp[46] NAND3_15/m1_n3706_n1374# GND nfet_03v3 ad=0 pd=0 as=0 ps=0 w=508 l=56
X1976 GND NAND3_15/a_2506_982# wl[47] GND nfet_03v3 ad=0 pd=0 as=0.10566u ps=2.448m w=508 l=56
X1977 GND NAND3_15/a_2506_982# wl[47] GND nfet_03v3 ad=0 pd=0 as=0 ps=0 w=508 l=56
X1978 wl[47] NAND3_15/a_2506_982# GND GND nfet_03v3 ad=0 pd=0 as=0 ps=0 w=508 l=56
X1979 wl[47] NAND3_15/a_2506_982# GND GND nfet_03v3 ad=0 pd=0 as=0 ps=0 w=508 l=56
X1980 VDD comp[37] NAND3_26/a_n593_982# VDD pfet_03v3 ad=0 pd=0 as=0.22308u ps=4.636m w=660 l=56
X1981 NAND3_26/a_n593_982# comp[37] VDD VDD pfet_03v3 ad=0 pd=0 as=0 ps=0 w=660 l=56
X1982 NAND3_26/a_n593_982# comp[37] VDD VDD pfet_03v3 ad=0 pd=0 as=0 ps=0 w=660 l=56
X1983 VDD comp[37] NAND3_26/a_n593_982# VDD pfet_03v3 ad=0 pd=0 as=0 ps=0 w=660 l=56
X1984 VDD comp[37] NAND3_26/a_n593_982# VDD pfet_03v3 ad=0 pd=0 as=0 ps=0 w=660 l=56
X1985 VDD comp[36] NAND3_26/a_2506_982# VDD pfet_03v3 ad=0 pd=0 as=0.66924u ps=0.01391 w=660 l=56
X1986 NAND3_26/a_2506_982# comp[36] VDD VDD pfet_03v3 ad=0 pd=0 as=0 ps=0 w=660 l=56
X1987 NAND3_26/a_2506_982# comp[36] VDD VDD pfet_03v3 ad=0 pd=0 as=0 ps=0 w=660 l=56
X1988 VDD comp[36] NAND3_26/a_2506_982# VDD pfet_03v3 ad=0 pd=0 as=0 ps=0 w=660 l=56
X1989 VDD comp[36] NAND3_26/a_2506_982# VDD pfet_03v3 ad=0 pd=0 as=0 ps=0 w=660 l=56
X1990 VDD comp[35] NAND3_26/a_2506_982# VDD pfet_03v3 ad=0 pd=0 as=0 ps=0 w=660 l=56
X1991 NAND3_26/a_2506_982# comp[35] VDD VDD pfet_03v3 ad=0 pd=0 as=0 ps=0 w=660 l=56
X1992 NAND3_26/a_2506_982# comp[35] VDD VDD pfet_03v3 ad=0 pd=0 as=0 ps=0 w=660 l=56
X1993 VDD comp[35] NAND3_26/a_2506_982# VDD pfet_03v3 ad=0 pd=0 as=0 ps=0 w=660 l=56
X1994 VDD comp[35] NAND3_26/a_2506_982# VDD pfet_03v3 ad=0 pd=0 as=0 ps=0 w=660 l=56
X1995 VDD NAND3_26/a_2506_982# wl[36] VDD pfet_03v3 ad=0 pd=0 as=0.22308u ps=4.636m w=660 l=56
X1996 wl[36] NAND3_26/a_2506_982# VDD VDD pfet_03v3 ad=0 pd=0 as=0 ps=0 w=660 l=56
X1997 wl[36] NAND3_26/a_2506_982# VDD VDD pfet_03v3 ad=0 pd=0 as=0 ps=0 w=660 l=56
X1998 VDD NAND3_26/a_2506_982# wl[36] VDD pfet_03v3 ad=0 pd=0 as=0 ps=0 w=660 l=56
X1999 VDD NAND3_26/a_2506_982# wl[36] VDD pfet_03v3 ad=0 pd=0 as=0 ps=0 w=660 l=56
X2000 VDD NAND3_26/a_n593_982# NAND3_26/a_2506_982# VDD pfet_03v3 ad=0 pd=0 as=0 ps=0 w=660 l=56
X2001 NAND3_26/a_2506_982# NAND3_26/a_n593_982# VDD VDD pfet_03v3 ad=0 pd=0 as=0 ps=0 w=660 l=56
X2002 NAND3_26/a_2506_982# NAND3_26/a_n593_982# VDD VDD pfet_03v3 ad=0 pd=0 as=0 ps=0 w=660 l=56
X2003 VDD NAND3_26/a_n593_982# NAND3_26/a_2506_982# VDD pfet_03v3 ad=0 pd=0 as=0 ps=0 w=660 l=56
X2004 VDD NAND3_26/a_n593_982# NAND3_26/a_2506_982# VDD pfet_03v3 ad=0 pd=0 as=0 ps=0 w=660 l=56
X2005 NAND3_26/m1_n2243_n1314# comp[36] NAND3_26/m1_n3706_n1374# GND nfet_03v3 ad=0.28245u pd=6.192m as=0.28245u ps=6.192m w=508 l=56
X2006 NAND3_26/m1_n2243_n1314# comp[36] NAND3_26/m1_n3706_n1374# GND nfet_03v3 ad=0 pd=0 as=0 ps=0 w=508 l=56
X2007 NAND3_26/m1_n3706_n1374# comp[36] NAND3_26/m1_n2243_n1314# GND nfet_03v3 ad=0 pd=0 as=0 ps=0 w=508 l=56
X2008 NAND3_26/m1_n3706_n1374# comp[36] NAND3_26/m1_n2243_n1314# GND nfet_03v3 ad=0 pd=0 as=0 ps=0 w=508 l=56
X2009 GND comp[37] NAND3_26/a_n593_982# GND nfet_03v3 ad=0 pd=0 as=0.10566u ps=2.448m w=508 l=56
X2010 GND comp[37] NAND3_26/a_n593_982# GND nfet_03v3 ad=0 pd=0 as=0 ps=0 w=508 l=56
X2011 NAND3_26/a_n593_982# comp[37] GND GND nfet_03v3 ad=0 pd=0 as=0 ps=0 w=508 l=56
X2012 NAND3_26/a_n593_982# comp[37] GND GND nfet_03v3 ad=0 pd=0 as=0 ps=0 w=508 l=56
X2013 GND NAND3_26/a_n593_982# NAND3_26/m1_n2243_n1314# GND nfet_03v3 ad=0 pd=0 as=0 ps=0 w=508 l=56
X2014 GND NAND3_26/a_n593_982# NAND3_26/m1_n2243_n1314# GND nfet_03v3 ad=0 pd=0 as=0 ps=0 w=508 l=56
X2015 NAND3_26/m1_n2243_n1314# NAND3_26/a_n593_982# GND GND nfet_03v3 ad=0 pd=0 as=0 ps=0 w=508 l=56
X2016 NAND3_26/m1_n2243_n1314# NAND3_26/a_n593_982# GND GND nfet_03v3 ad=0 pd=0 as=0 ps=0 w=508 l=56
X2017 NAND3_26/m1_n3706_n1374# comp[35] NAND3_26/a_2506_982# GND nfet_03v3 ad=0 pd=0 as=0.10566u ps=2.448m w=508 l=56
X2018 NAND3_26/m1_n3706_n1374# comp[35] NAND3_26/a_2506_982# GND nfet_03v3 ad=0 pd=0 as=0 ps=0 w=508 l=56
X2019 NAND3_26/a_2506_982# comp[35] NAND3_26/m1_n3706_n1374# GND nfet_03v3 ad=0 pd=0 as=0 ps=0 w=508 l=56
X2020 NAND3_26/a_2506_982# comp[35] NAND3_26/m1_n3706_n1374# GND nfet_03v3 ad=0 pd=0 as=0 ps=0 w=508 l=56
X2021 GND NAND3_26/a_2506_982# wl[36] GND nfet_03v3 ad=0 pd=0 as=0.10566u ps=2.448m w=508 l=56
X2022 GND NAND3_26/a_2506_982# wl[36] GND nfet_03v3 ad=0 pd=0 as=0 ps=0 w=508 l=56
X2023 wl[36] NAND3_26/a_2506_982# GND GND nfet_03v3 ad=0 pd=0 as=0 ps=0 w=508 l=56
X2024 wl[36] NAND3_26/a_2506_982# GND GND nfet_03v3 ad=0 pd=0 as=0 ps=0 w=508 l=56
X2025 VDD comp[26] NAND3_37/a_n593_982# VDD pfet_03v3 ad=0 pd=0 as=0.22308u ps=4.636m w=660 l=56
X2026 NAND3_37/a_n593_982# comp[26] VDD VDD pfet_03v3 ad=0 pd=0 as=0 ps=0 w=660 l=56
X2027 NAND3_37/a_n593_982# comp[26] VDD VDD pfet_03v3 ad=0 pd=0 as=0 ps=0 w=660 l=56
X2028 VDD comp[26] NAND3_37/a_n593_982# VDD pfet_03v3 ad=0 pd=0 as=0 ps=0 w=660 l=56
X2029 VDD comp[26] NAND3_37/a_n593_982# VDD pfet_03v3 ad=0 pd=0 as=0 ps=0 w=660 l=56
X2030 VDD comp[25] NAND3_37/a_2506_982# VDD pfet_03v3 ad=0 pd=0 as=0.66924u ps=0.01391 w=660 l=56
X2031 NAND3_37/a_2506_982# comp[25] VDD VDD pfet_03v3 ad=0 pd=0 as=0 ps=0 w=660 l=56
X2032 NAND3_37/a_2506_982# comp[25] VDD VDD pfet_03v3 ad=0 pd=0 as=0 ps=0 w=660 l=56
X2033 VDD comp[25] NAND3_37/a_2506_982# VDD pfet_03v3 ad=0 pd=0 as=0 ps=0 w=660 l=56
X2034 VDD comp[25] NAND3_37/a_2506_982# VDD pfet_03v3 ad=0 pd=0 as=0 ps=0 w=660 l=56
X2035 VDD comp[24] NAND3_37/a_2506_982# VDD pfet_03v3 ad=0 pd=0 as=0 ps=0 w=660 l=56
X2036 NAND3_37/a_2506_982# comp[24] VDD VDD pfet_03v3 ad=0 pd=0 as=0 ps=0 w=660 l=56
X2037 NAND3_37/a_2506_982# comp[24] VDD VDD pfet_03v3 ad=0 pd=0 as=0 ps=0 w=660 l=56
X2038 VDD comp[24] NAND3_37/a_2506_982# VDD pfet_03v3 ad=0 pd=0 as=0 ps=0 w=660 l=56
X2039 VDD comp[24] NAND3_37/a_2506_982# VDD pfet_03v3 ad=0 pd=0 as=0 ps=0 w=660 l=56
X2040 VDD NAND3_37/a_2506_982# wl[25] VDD pfet_03v3 ad=0 pd=0 as=0.22308u ps=4.636m w=660 l=56
X2041 wl[25] NAND3_37/a_2506_982# VDD VDD pfet_03v3 ad=0 pd=0 as=0 ps=0 w=660 l=56
X2042 wl[25] NAND3_37/a_2506_982# VDD VDD pfet_03v3 ad=0 pd=0 as=0 ps=0 w=660 l=56
X2043 VDD NAND3_37/a_2506_982# wl[25] VDD pfet_03v3 ad=0 pd=0 as=0 ps=0 w=660 l=56
X2044 VDD NAND3_37/a_2506_982# wl[25] VDD pfet_03v3 ad=0 pd=0 as=0 ps=0 w=660 l=56
X2045 VDD NAND3_37/a_n593_982# NAND3_37/a_2506_982# VDD pfet_03v3 ad=0 pd=0 as=0 ps=0 w=660 l=56
X2046 NAND3_37/a_2506_982# NAND3_37/a_n593_982# VDD VDD pfet_03v3 ad=0 pd=0 as=0 ps=0 w=660 l=56
X2047 NAND3_37/a_2506_982# NAND3_37/a_n593_982# VDD VDD pfet_03v3 ad=0 pd=0 as=0 ps=0 w=660 l=56
X2048 VDD NAND3_37/a_n593_982# NAND3_37/a_2506_982# VDD pfet_03v3 ad=0 pd=0 as=0 ps=0 w=660 l=56
X2049 VDD NAND3_37/a_n593_982# NAND3_37/a_2506_982# VDD pfet_03v3 ad=0 pd=0 as=0 ps=0 w=660 l=56
X2050 NAND3_37/m1_n2243_n1314# comp[25] NAND3_37/m1_n3706_n1374# GND nfet_03v3 ad=0.28245u pd=6.192m as=0.28245u ps=6.192m w=508 l=56
X2051 NAND3_37/m1_n2243_n1314# comp[25] NAND3_37/m1_n3706_n1374# GND nfet_03v3 ad=0 pd=0 as=0 ps=0 w=508 l=56
X2052 NAND3_37/m1_n3706_n1374# comp[25] NAND3_37/m1_n2243_n1314# GND nfet_03v3 ad=0 pd=0 as=0 ps=0 w=508 l=56
X2053 NAND3_37/m1_n3706_n1374# comp[25] NAND3_37/m1_n2243_n1314# GND nfet_03v3 ad=0 pd=0 as=0 ps=0 w=508 l=56
X2054 GND comp[26] NAND3_37/a_n593_982# GND nfet_03v3 ad=0 pd=0 as=0.10566u ps=2.448m w=508 l=56
X2055 GND comp[26] NAND3_37/a_n593_982# GND nfet_03v3 ad=0 pd=0 as=0 ps=0 w=508 l=56
X2056 NAND3_37/a_n593_982# comp[26] GND GND nfet_03v3 ad=0 pd=0 as=0 ps=0 w=508 l=56
X2057 NAND3_37/a_n593_982# comp[26] GND GND nfet_03v3 ad=0 pd=0 as=0 ps=0 w=508 l=56
X2058 GND NAND3_37/a_n593_982# NAND3_37/m1_n2243_n1314# GND nfet_03v3 ad=0 pd=0 as=0 ps=0 w=508 l=56
X2059 GND NAND3_37/a_n593_982# NAND3_37/m1_n2243_n1314# GND nfet_03v3 ad=0 pd=0 as=0 ps=0 w=508 l=56
X2060 NAND3_37/m1_n2243_n1314# NAND3_37/a_n593_982# GND GND nfet_03v3 ad=0 pd=0 as=0 ps=0 w=508 l=56
X2061 NAND3_37/m1_n2243_n1314# NAND3_37/a_n593_982# GND GND nfet_03v3 ad=0 pd=0 as=0 ps=0 w=508 l=56
X2062 NAND3_37/m1_n3706_n1374# comp[24] NAND3_37/a_2506_982# GND nfet_03v3 ad=0 pd=0 as=0.10566u ps=2.448m w=508 l=56
X2063 NAND3_37/m1_n3706_n1374# comp[24] NAND3_37/a_2506_982# GND nfet_03v3 ad=0 pd=0 as=0 ps=0 w=508 l=56
X2064 NAND3_37/a_2506_982# comp[24] NAND3_37/m1_n3706_n1374# GND nfet_03v3 ad=0 pd=0 as=0 ps=0 w=508 l=56
X2065 NAND3_37/a_2506_982# comp[24] NAND3_37/m1_n3706_n1374# GND nfet_03v3 ad=0 pd=0 as=0 ps=0 w=508 l=56
X2066 GND NAND3_37/a_2506_982# wl[25] GND nfet_03v3 ad=0 pd=0 as=0.10566u ps=2.448m w=508 l=56
X2067 GND NAND3_37/a_2506_982# wl[25] GND nfet_03v3 ad=0 pd=0 as=0 ps=0 w=508 l=56
X2068 wl[25] NAND3_37/a_2506_982# GND GND nfet_03v3 ad=0 pd=0 as=0 ps=0 w=508 l=56
X2069 wl[25] NAND3_37/a_2506_982# GND GND nfet_03v3 ad=0 pd=0 as=0 ps=0 w=508 l=56
X2070 VDD comp[15] NAND3_48/a_n593_982# VDD pfet_03v3 ad=0 pd=0 as=0.22308u ps=4.636m w=660 l=56
X2071 NAND3_48/a_n593_982# comp[15] VDD VDD pfet_03v3 ad=0 pd=0 as=0 ps=0 w=660 l=56
X2072 NAND3_48/a_n593_982# comp[15] VDD VDD pfet_03v3 ad=0 pd=0 as=0 ps=0 w=660 l=56
X2073 VDD comp[15] NAND3_48/a_n593_982# VDD pfet_03v3 ad=0 pd=0 as=0 ps=0 w=660 l=56
X2074 VDD comp[15] NAND3_48/a_n593_982# VDD pfet_03v3 ad=0 pd=0 as=0 ps=0 w=660 l=56
X2075 VDD comp[14] NAND3_48/a_2506_982# VDD pfet_03v3 ad=0 pd=0 as=0.66924u ps=0.01391 w=660 l=56
X2076 NAND3_48/a_2506_982# comp[14] VDD VDD pfet_03v3 ad=0 pd=0 as=0 ps=0 w=660 l=56
X2077 NAND3_48/a_2506_982# comp[14] VDD VDD pfet_03v3 ad=0 pd=0 as=0 ps=0 w=660 l=56
X2078 VDD comp[14] NAND3_48/a_2506_982# VDD pfet_03v3 ad=0 pd=0 as=0 ps=0 w=660 l=56
X2079 VDD comp[14] NAND3_48/a_2506_982# VDD pfet_03v3 ad=0 pd=0 as=0 ps=0 w=660 l=56
X2080 VDD comp[13] NAND3_48/a_2506_982# VDD pfet_03v3 ad=0 pd=0 as=0 ps=0 w=660 l=56
X2081 NAND3_48/a_2506_982# comp[13] VDD VDD pfet_03v3 ad=0 pd=0 as=0 ps=0 w=660 l=56
X2082 NAND3_48/a_2506_982# comp[13] VDD VDD pfet_03v3 ad=0 pd=0 as=0 ps=0 w=660 l=56
X2083 VDD comp[13] NAND3_48/a_2506_982# VDD pfet_03v3 ad=0 pd=0 as=0 ps=0 w=660 l=56
X2084 VDD comp[13] NAND3_48/a_2506_982# VDD pfet_03v3 ad=0 pd=0 as=0 ps=0 w=660 l=56
X2085 VDD NAND3_48/a_2506_982# wl[14] VDD pfet_03v3 ad=0 pd=0 as=0.22308u ps=4.636m w=660 l=56
X2086 wl[14] NAND3_48/a_2506_982# VDD VDD pfet_03v3 ad=0 pd=0 as=0 ps=0 w=660 l=56
X2087 wl[14] NAND3_48/a_2506_982# VDD VDD pfet_03v3 ad=0 pd=0 as=0 ps=0 w=660 l=56
X2088 VDD NAND3_48/a_2506_982# wl[14] VDD pfet_03v3 ad=0 pd=0 as=0 ps=0 w=660 l=56
X2089 VDD NAND3_48/a_2506_982# wl[14] VDD pfet_03v3 ad=0 pd=0 as=0 ps=0 w=660 l=56
X2090 VDD NAND3_48/a_n593_982# NAND3_48/a_2506_982# VDD pfet_03v3 ad=0 pd=0 as=0 ps=0 w=660 l=56
X2091 NAND3_48/a_2506_982# NAND3_48/a_n593_982# VDD VDD pfet_03v3 ad=0 pd=0 as=0 ps=0 w=660 l=56
X2092 NAND3_48/a_2506_982# NAND3_48/a_n593_982# VDD VDD pfet_03v3 ad=0 pd=0 as=0 ps=0 w=660 l=56
X2093 VDD NAND3_48/a_n593_982# NAND3_48/a_2506_982# VDD pfet_03v3 ad=0 pd=0 as=0 ps=0 w=660 l=56
X2094 VDD NAND3_48/a_n593_982# NAND3_48/a_2506_982# VDD pfet_03v3 ad=0 pd=0 as=0 ps=0 w=660 l=56
X2095 NAND3_48/m1_n2243_n1314# comp[14] NAND3_48/m1_n3706_n1374# GND nfet_03v3 ad=0.28245u pd=6.192m as=0.28245u ps=6.192m w=508 l=56
X2096 NAND3_48/m1_n2243_n1314# comp[14] NAND3_48/m1_n3706_n1374# GND nfet_03v3 ad=0 pd=0 as=0 ps=0 w=508 l=56
X2097 NAND3_48/m1_n3706_n1374# comp[14] NAND3_48/m1_n2243_n1314# GND nfet_03v3 ad=0 pd=0 as=0 ps=0 w=508 l=56
X2098 NAND3_48/m1_n3706_n1374# comp[14] NAND3_48/m1_n2243_n1314# GND nfet_03v3 ad=0 pd=0 as=0 ps=0 w=508 l=56
X2099 GND comp[15] NAND3_48/a_n593_982# GND nfet_03v3 ad=0 pd=0 as=0.10566u ps=2.448m w=508 l=56
X2100 GND comp[15] NAND3_48/a_n593_982# GND nfet_03v3 ad=0 pd=0 as=0 ps=0 w=508 l=56
X2101 NAND3_48/a_n593_982# comp[15] GND GND nfet_03v3 ad=0 pd=0 as=0 ps=0 w=508 l=56
X2102 NAND3_48/a_n593_982# comp[15] GND GND nfet_03v3 ad=0 pd=0 as=0 ps=0 w=508 l=56
X2103 GND NAND3_48/a_n593_982# NAND3_48/m1_n2243_n1314# GND nfet_03v3 ad=0 pd=0 as=0 ps=0 w=508 l=56
X2104 GND NAND3_48/a_n593_982# NAND3_48/m1_n2243_n1314# GND nfet_03v3 ad=0 pd=0 as=0 ps=0 w=508 l=56
X2105 NAND3_48/m1_n2243_n1314# NAND3_48/a_n593_982# GND GND nfet_03v3 ad=0 pd=0 as=0 ps=0 w=508 l=56
X2106 NAND3_48/m1_n2243_n1314# NAND3_48/a_n593_982# GND GND nfet_03v3 ad=0 pd=0 as=0 ps=0 w=508 l=56
X2107 NAND3_48/m1_n3706_n1374# comp[13] NAND3_48/a_2506_982# GND nfet_03v3 ad=0 pd=0 as=0.10566u ps=2.448m w=508 l=56
X2108 NAND3_48/m1_n3706_n1374# comp[13] NAND3_48/a_2506_982# GND nfet_03v3 ad=0 pd=0 as=0 ps=0 w=508 l=56
X2109 NAND3_48/a_2506_982# comp[13] NAND3_48/m1_n3706_n1374# GND nfet_03v3 ad=0 pd=0 as=0 ps=0 w=508 l=56
X2110 NAND3_48/a_2506_982# comp[13] NAND3_48/m1_n3706_n1374# GND nfet_03v3 ad=0 pd=0 as=0 ps=0 w=508 l=56
X2111 GND NAND3_48/a_2506_982# wl[14] GND nfet_03v3 ad=0 pd=0 as=0.10566u ps=2.448m w=508 l=56
X2112 GND NAND3_48/a_2506_982# wl[14] GND nfet_03v3 ad=0 pd=0 as=0 ps=0 w=508 l=56
X2113 wl[14] NAND3_48/a_2506_982# GND GND nfet_03v3 ad=0 pd=0 as=0 ps=0 w=508 l=56
X2114 wl[14] NAND3_48/a_2506_982# GND GND nfet_03v3 ad=0 pd=0 as=0 ps=0 w=508 l=56
X2115 VDD comp[4] NAND3_59/a_n593_982# VDD pfet_03v3 ad=0 pd=0 as=0.22308u ps=4.636m w=660 l=56
X2116 NAND3_59/a_n593_982# comp[4] VDD VDD pfet_03v3 ad=0 pd=0 as=0 ps=0 w=660 l=56
X2117 NAND3_59/a_n593_982# comp[4] VDD VDD pfet_03v3 ad=0 pd=0 as=0 ps=0 w=660 l=56
X2118 VDD comp[4] NAND3_59/a_n593_982# VDD pfet_03v3 ad=0 pd=0 as=0 ps=0 w=660 l=56
X2119 VDD comp[4] NAND3_59/a_n593_982# VDD pfet_03v3 ad=0 pd=0 as=0 ps=0 w=660 l=56
X2120 VDD comp[3] NAND3_59/a_2506_982# VDD pfet_03v3 ad=0 pd=0 as=0.66924u ps=0.01391 w=660 l=56
X2121 NAND3_59/a_2506_982# comp[3] VDD VDD pfet_03v3 ad=0 pd=0 as=0 ps=0 w=660 l=56
X2122 NAND3_59/a_2506_982# comp[3] VDD VDD pfet_03v3 ad=0 pd=0 as=0 ps=0 w=660 l=56
X2123 VDD comp[3] NAND3_59/a_2506_982# VDD pfet_03v3 ad=0 pd=0 as=0 ps=0 w=660 l=56
X2124 VDD comp[3] NAND3_59/a_2506_982# VDD pfet_03v3 ad=0 pd=0 as=0 ps=0 w=660 l=56
X2125 VDD comp[2] NAND3_59/a_2506_982# VDD pfet_03v3 ad=0 pd=0 as=0 ps=0 w=660 l=56
X2126 NAND3_59/a_2506_982# comp[2] VDD VDD pfet_03v3 ad=0 pd=0 as=0 ps=0 w=660 l=56
X2127 NAND3_59/a_2506_982# comp[2] VDD VDD pfet_03v3 ad=0 pd=0 as=0 ps=0 w=660 l=56
X2128 VDD comp[2] NAND3_59/a_2506_982# VDD pfet_03v3 ad=0 pd=0 as=0 ps=0 w=660 l=56
X2129 VDD comp[2] NAND3_59/a_2506_982# VDD pfet_03v3 ad=0 pd=0 as=0 ps=0 w=660 l=56
X2130 VDD NAND3_59/a_2506_982# wl[3] VDD pfet_03v3 ad=0 pd=0 as=0.22308u ps=4.636m w=660 l=56
X2131 wl[3] NAND3_59/a_2506_982# VDD VDD pfet_03v3 ad=0 pd=0 as=0 ps=0 w=660 l=56
X2132 wl[3] NAND3_59/a_2506_982# VDD VDD pfet_03v3 ad=0 pd=0 as=0 ps=0 w=660 l=56
X2133 VDD NAND3_59/a_2506_982# wl[3] VDD pfet_03v3 ad=0 pd=0 as=0 ps=0 w=660 l=56
X2134 VDD NAND3_59/a_2506_982# wl[3] VDD pfet_03v3 ad=0 pd=0 as=0 ps=0 w=660 l=56
X2135 VDD NAND3_59/a_n593_982# NAND3_59/a_2506_982# VDD pfet_03v3 ad=0 pd=0 as=0 ps=0 w=660 l=56
X2136 NAND3_59/a_2506_982# NAND3_59/a_n593_982# VDD VDD pfet_03v3 ad=0 pd=0 as=0 ps=0 w=660 l=56
X2137 NAND3_59/a_2506_982# NAND3_59/a_n593_982# VDD VDD pfet_03v3 ad=0 pd=0 as=0 ps=0 w=660 l=56
X2138 VDD NAND3_59/a_n593_982# NAND3_59/a_2506_982# VDD pfet_03v3 ad=0 pd=0 as=0 ps=0 w=660 l=56
X2139 VDD NAND3_59/a_n593_982# NAND3_59/a_2506_982# VDD pfet_03v3 ad=0 pd=0 as=0 ps=0 w=660 l=56
X2140 NAND3_59/m1_n2243_n1314# comp[3] NAND3_59/m1_n3706_n1374# GND nfet_03v3 ad=0.28245u pd=6.192m as=0.28245u ps=6.192m w=508 l=56
X2141 NAND3_59/m1_n2243_n1314# comp[3] NAND3_59/m1_n3706_n1374# GND nfet_03v3 ad=0 pd=0 as=0 ps=0 w=508 l=56
X2142 NAND3_59/m1_n3706_n1374# comp[3] NAND3_59/m1_n2243_n1314# GND nfet_03v3 ad=0 pd=0 as=0 ps=0 w=508 l=56
X2143 NAND3_59/m1_n3706_n1374# comp[3] NAND3_59/m1_n2243_n1314# GND nfet_03v3 ad=0 pd=0 as=0 ps=0 w=508 l=56
X2144 GND comp[4] NAND3_59/a_n593_982# GND nfet_03v3 ad=0 pd=0 as=0.10566u ps=2.448m w=508 l=56
X2145 GND comp[4] NAND3_59/a_n593_982# GND nfet_03v3 ad=0 pd=0 as=0 ps=0 w=508 l=56
X2146 NAND3_59/a_n593_982# comp[4] GND GND nfet_03v3 ad=0 pd=0 as=0 ps=0 w=508 l=56
X2147 NAND3_59/a_n593_982# comp[4] GND GND nfet_03v3 ad=0 pd=0 as=0 ps=0 w=508 l=56
X2148 GND NAND3_59/a_n593_982# NAND3_59/m1_n2243_n1314# GND nfet_03v3 ad=0 pd=0 as=0 ps=0 w=508 l=56
X2149 GND NAND3_59/a_n593_982# NAND3_59/m1_n2243_n1314# GND nfet_03v3 ad=0 pd=0 as=0 ps=0 w=508 l=56
X2150 NAND3_59/m1_n2243_n1314# NAND3_59/a_n593_982# GND GND nfet_03v3 ad=0 pd=0 as=0 ps=0 w=508 l=56
X2151 NAND3_59/m1_n2243_n1314# NAND3_59/a_n593_982# GND GND nfet_03v3 ad=0 pd=0 as=0 ps=0 w=508 l=56
X2152 NAND3_59/m1_n3706_n1374# comp[2] NAND3_59/a_2506_982# GND nfet_03v3 ad=0 pd=0 as=0.10566u ps=2.448m w=508 l=56
X2153 NAND3_59/m1_n3706_n1374# comp[2] NAND3_59/a_2506_982# GND nfet_03v3 ad=0 pd=0 as=0 ps=0 w=508 l=56
X2154 NAND3_59/a_2506_982# comp[2] NAND3_59/m1_n3706_n1374# GND nfet_03v3 ad=0 pd=0 as=0 ps=0 w=508 l=56
X2155 NAND3_59/a_2506_982# comp[2] NAND3_59/m1_n3706_n1374# GND nfet_03v3 ad=0 pd=0 as=0 ps=0 w=508 l=56
X2156 GND NAND3_59/a_2506_982# wl[3] GND nfet_03v3 ad=0 pd=0 as=0.10566u ps=2.448m w=508 l=56
X2157 GND NAND3_59/a_2506_982# wl[3] GND nfet_03v3 ad=0 pd=0 as=0 ps=0 w=508 l=56
X2158 wl[3] NAND3_59/a_2506_982# GND GND nfet_03v3 ad=0 pd=0 as=0 ps=0 w=508 l=56
X2159 wl[3] NAND3_59/a_2506_982# GND GND nfet_03v3 ad=0 pd=0 as=0 ps=0 w=508 l=56
X2160 VDD comp[58] NAND3_5/a_n593_982# VDD pfet_03v3 ad=0 pd=0 as=0.22308u ps=4.636m w=660 l=56
X2161 NAND3_5/a_n593_982# comp[58] VDD VDD pfet_03v3 ad=0 pd=0 as=0 ps=0 w=660 l=56
X2162 NAND3_5/a_n593_982# comp[58] VDD VDD pfet_03v3 ad=0 pd=0 as=0 ps=0 w=660 l=56
X2163 VDD comp[58] NAND3_5/a_n593_982# VDD pfet_03v3 ad=0 pd=0 as=0 ps=0 w=660 l=56
X2164 VDD comp[58] NAND3_5/a_n593_982# VDD pfet_03v3 ad=0 pd=0 as=0 ps=0 w=660 l=56
X2165 VDD comp[57] NAND3_5/a_2506_982# VDD pfet_03v3 ad=0 pd=0 as=0.66924u ps=0.01391 w=660 l=56
X2166 NAND3_5/a_2506_982# comp[57] VDD VDD pfet_03v3 ad=0 pd=0 as=0 ps=0 w=660 l=56
X2167 NAND3_5/a_2506_982# comp[57] VDD VDD pfet_03v3 ad=0 pd=0 as=0 ps=0 w=660 l=56
X2168 VDD comp[57] NAND3_5/a_2506_982# VDD pfet_03v3 ad=0 pd=0 as=0 ps=0 w=660 l=56
X2169 VDD comp[57] NAND3_5/a_2506_982# VDD pfet_03v3 ad=0 pd=0 as=0 ps=0 w=660 l=56
X2170 VDD comp[56] NAND3_5/a_2506_982# VDD pfet_03v3 ad=0 pd=0 as=0 ps=0 w=660 l=56
X2171 NAND3_5/a_2506_982# comp[56] VDD VDD pfet_03v3 ad=0 pd=0 as=0 ps=0 w=660 l=56
X2172 NAND3_5/a_2506_982# comp[56] VDD VDD pfet_03v3 ad=0 pd=0 as=0 ps=0 w=660 l=56
X2173 VDD comp[56] NAND3_5/a_2506_982# VDD pfet_03v3 ad=0 pd=0 as=0 ps=0 w=660 l=56
X2174 VDD comp[56] NAND3_5/a_2506_982# VDD pfet_03v3 ad=0 pd=0 as=0 ps=0 w=660 l=56
X2175 VDD NAND3_5/a_2506_982# wl[57] VDD pfet_03v3 ad=0 pd=0 as=0.22308u ps=4.636m w=660 l=56
X2176 wl[57] NAND3_5/a_2506_982# VDD VDD pfet_03v3 ad=0 pd=0 as=0 ps=0 w=660 l=56
X2177 wl[57] NAND3_5/a_2506_982# VDD VDD pfet_03v3 ad=0 pd=0 as=0 ps=0 w=660 l=56
X2178 VDD NAND3_5/a_2506_982# wl[57] VDD pfet_03v3 ad=0 pd=0 as=0 ps=0 w=660 l=56
X2179 VDD NAND3_5/a_2506_982# wl[57] VDD pfet_03v3 ad=0 pd=0 as=0 ps=0 w=660 l=56
X2180 VDD NAND3_5/a_n593_982# NAND3_5/a_2506_982# VDD pfet_03v3 ad=0 pd=0 as=0 ps=0 w=660 l=56
X2181 NAND3_5/a_2506_982# NAND3_5/a_n593_982# VDD VDD pfet_03v3 ad=0 pd=0 as=0 ps=0 w=660 l=56
X2182 NAND3_5/a_2506_982# NAND3_5/a_n593_982# VDD VDD pfet_03v3 ad=0 pd=0 as=0 ps=0 w=660 l=56
X2183 VDD NAND3_5/a_n593_982# NAND3_5/a_2506_982# VDD pfet_03v3 ad=0 pd=0 as=0 ps=0 w=660 l=56
X2184 VDD NAND3_5/a_n593_982# NAND3_5/a_2506_982# VDD pfet_03v3 ad=0 pd=0 as=0 ps=0 w=660 l=56
X2185 NAND3_5/m1_n2243_n1314# comp[57] NAND3_5/m1_n3706_n1374# GND nfet_03v3 ad=0.28245u pd=6.192m as=0.28245u ps=6.192m w=508 l=56
X2186 NAND3_5/m1_n2243_n1314# comp[57] NAND3_5/m1_n3706_n1374# GND nfet_03v3 ad=0 pd=0 as=0 ps=0 w=508 l=56
X2187 NAND3_5/m1_n3706_n1374# comp[57] NAND3_5/m1_n2243_n1314# GND nfet_03v3 ad=0 pd=0 as=0 ps=0 w=508 l=56
X2188 NAND3_5/m1_n3706_n1374# comp[57] NAND3_5/m1_n2243_n1314# GND nfet_03v3 ad=0 pd=0 as=0 ps=0 w=508 l=56
X2189 GND comp[58] NAND3_5/a_n593_982# GND nfet_03v3 ad=0 pd=0 as=0.10566u ps=2.448m w=508 l=56
X2190 GND comp[58] NAND3_5/a_n593_982# GND nfet_03v3 ad=0 pd=0 as=0 ps=0 w=508 l=56
X2191 NAND3_5/a_n593_982# comp[58] GND GND nfet_03v3 ad=0 pd=0 as=0 ps=0 w=508 l=56
X2192 NAND3_5/a_n593_982# comp[58] GND GND nfet_03v3 ad=0 pd=0 as=0 ps=0 w=508 l=56
X2193 GND NAND3_5/a_n593_982# NAND3_5/m1_n2243_n1314# GND nfet_03v3 ad=0 pd=0 as=0 ps=0 w=508 l=56
X2194 GND NAND3_5/a_n593_982# NAND3_5/m1_n2243_n1314# GND nfet_03v3 ad=0 pd=0 as=0 ps=0 w=508 l=56
X2195 NAND3_5/m1_n2243_n1314# NAND3_5/a_n593_982# GND GND nfet_03v3 ad=0 pd=0 as=0 ps=0 w=508 l=56
X2196 NAND3_5/m1_n2243_n1314# NAND3_5/a_n593_982# GND GND nfet_03v3 ad=0 pd=0 as=0 ps=0 w=508 l=56
X2197 NAND3_5/m1_n3706_n1374# comp[56] NAND3_5/a_2506_982# GND nfet_03v3 ad=0 pd=0 as=0.10566u ps=2.448m w=508 l=56
X2198 NAND3_5/m1_n3706_n1374# comp[56] NAND3_5/a_2506_982# GND nfet_03v3 ad=0 pd=0 as=0 ps=0 w=508 l=56
X2199 NAND3_5/a_2506_982# comp[56] NAND3_5/m1_n3706_n1374# GND nfet_03v3 ad=0 pd=0 as=0 ps=0 w=508 l=56
X2200 NAND3_5/a_2506_982# comp[56] NAND3_5/m1_n3706_n1374# GND nfet_03v3 ad=0 pd=0 as=0 ps=0 w=508 l=56
X2201 GND NAND3_5/a_2506_982# wl[57] GND nfet_03v3 ad=0 pd=0 as=0.10566u ps=2.448m w=508 l=56
X2202 GND NAND3_5/a_2506_982# wl[57] GND nfet_03v3 ad=0 pd=0 as=0 ps=0 w=508 l=56
X2203 wl[57] NAND3_5/a_2506_982# GND GND nfet_03v3 ad=0 pd=0 as=0 ps=0 w=508 l=56
X2204 wl[57] NAND3_5/a_2506_982# GND GND nfet_03v3 ad=0 pd=0 as=0 ps=0 w=508 l=56
X2205 VDD comp[57] NAND3_6/a_n593_982# VDD pfet_03v3 ad=0 pd=0 as=0.22308u ps=4.636m w=660 l=56
X2206 NAND3_6/a_n593_982# comp[57] VDD VDD pfet_03v3 ad=0 pd=0 as=0 ps=0 w=660 l=56
X2207 NAND3_6/a_n593_982# comp[57] VDD VDD pfet_03v3 ad=0 pd=0 as=0 ps=0 w=660 l=56
X2208 VDD comp[57] NAND3_6/a_n593_982# VDD pfet_03v3 ad=0 pd=0 as=0 ps=0 w=660 l=56
X2209 VDD comp[57] NAND3_6/a_n593_982# VDD pfet_03v3 ad=0 pd=0 as=0 ps=0 w=660 l=56
X2210 VDD comp[56] NAND3_6/a_2506_982# VDD pfet_03v3 ad=0 pd=0 as=0.66924u ps=0.01391 w=660 l=56
X2211 NAND3_6/a_2506_982# comp[56] VDD VDD pfet_03v3 ad=0 pd=0 as=0 ps=0 w=660 l=56
X2212 NAND3_6/a_2506_982# comp[56] VDD VDD pfet_03v3 ad=0 pd=0 as=0 ps=0 w=660 l=56
X2213 VDD comp[56] NAND3_6/a_2506_982# VDD pfet_03v3 ad=0 pd=0 as=0 ps=0 w=660 l=56
X2214 VDD comp[56] NAND3_6/a_2506_982# VDD pfet_03v3 ad=0 pd=0 as=0 ps=0 w=660 l=56
X2215 VDD comp[55] NAND3_6/a_2506_982# VDD pfet_03v3 ad=0 pd=0 as=0 ps=0 w=660 l=56
X2216 NAND3_6/a_2506_982# comp[55] VDD VDD pfet_03v3 ad=0 pd=0 as=0 ps=0 w=660 l=56
X2217 NAND3_6/a_2506_982# comp[55] VDD VDD pfet_03v3 ad=0 pd=0 as=0 ps=0 w=660 l=56
X2218 VDD comp[55] NAND3_6/a_2506_982# VDD pfet_03v3 ad=0 pd=0 as=0 ps=0 w=660 l=56
X2219 VDD comp[55] NAND3_6/a_2506_982# VDD pfet_03v3 ad=0 pd=0 as=0 ps=0 w=660 l=56
X2220 VDD NAND3_6/a_2506_982# wl[56] VDD pfet_03v3 ad=0 pd=0 as=0.22308u ps=4.636m w=660 l=56
X2221 wl[56] NAND3_6/a_2506_982# VDD VDD pfet_03v3 ad=0 pd=0 as=0 ps=0 w=660 l=56
X2222 wl[56] NAND3_6/a_2506_982# VDD VDD pfet_03v3 ad=0 pd=0 as=0 ps=0 w=660 l=56
X2223 VDD NAND3_6/a_2506_982# wl[56] VDD pfet_03v3 ad=0 pd=0 as=0 ps=0 w=660 l=56
X2224 VDD NAND3_6/a_2506_982# wl[56] VDD pfet_03v3 ad=0 pd=0 as=0 ps=0 w=660 l=56
X2225 VDD NAND3_6/a_n593_982# NAND3_6/a_2506_982# VDD pfet_03v3 ad=0 pd=0 as=0 ps=0 w=660 l=56
X2226 NAND3_6/a_2506_982# NAND3_6/a_n593_982# VDD VDD pfet_03v3 ad=0 pd=0 as=0 ps=0 w=660 l=56
X2227 NAND3_6/a_2506_982# NAND3_6/a_n593_982# VDD VDD pfet_03v3 ad=0 pd=0 as=0 ps=0 w=660 l=56
X2228 VDD NAND3_6/a_n593_982# NAND3_6/a_2506_982# VDD pfet_03v3 ad=0 pd=0 as=0 ps=0 w=660 l=56
X2229 VDD NAND3_6/a_n593_982# NAND3_6/a_2506_982# VDD pfet_03v3 ad=0 pd=0 as=0 ps=0 w=660 l=56
X2230 NAND3_6/m1_n2243_n1314# comp[56] NAND3_6/m1_n3706_n1374# GND nfet_03v3 ad=0.28245u pd=6.192m as=0.28245u ps=6.192m w=508 l=56
X2231 NAND3_6/m1_n2243_n1314# comp[56] NAND3_6/m1_n3706_n1374# GND nfet_03v3 ad=0 pd=0 as=0 ps=0 w=508 l=56
X2232 NAND3_6/m1_n3706_n1374# comp[56] NAND3_6/m1_n2243_n1314# GND nfet_03v3 ad=0 pd=0 as=0 ps=0 w=508 l=56
X2233 NAND3_6/m1_n3706_n1374# comp[56] NAND3_6/m1_n2243_n1314# GND nfet_03v3 ad=0 pd=0 as=0 ps=0 w=508 l=56
X2234 GND comp[57] NAND3_6/a_n593_982# GND nfet_03v3 ad=0 pd=0 as=0.10566u ps=2.448m w=508 l=56
X2235 GND comp[57] NAND3_6/a_n593_982# GND nfet_03v3 ad=0 pd=0 as=0 ps=0 w=508 l=56
X2236 NAND3_6/a_n593_982# comp[57] GND GND nfet_03v3 ad=0 pd=0 as=0 ps=0 w=508 l=56
X2237 NAND3_6/a_n593_982# comp[57] GND GND nfet_03v3 ad=0 pd=0 as=0 ps=0 w=508 l=56
X2238 GND NAND3_6/a_n593_982# NAND3_6/m1_n2243_n1314# GND nfet_03v3 ad=0 pd=0 as=0 ps=0 w=508 l=56
X2239 GND NAND3_6/a_n593_982# NAND3_6/m1_n2243_n1314# GND nfet_03v3 ad=0 pd=0 as=0 ps=0 w=508 l=56
X2240 NAND3_6/m1_n2243_n1314# NAND3_6/a_n593_982# GND GND nfet_03v3 ad=0 pd=0 as=0 ps=0 w=508 l=56
X2241 NAND3_6/m1_n2243_n1314# NAND3_6/a_n593_982# GND GND nfet_03v3 ad=0 pd=0 as=0 ps=0 w=508 l=56
X2242 NAND3_6/m1_n3706_n1374# comp[55] NAND3_6/a_2506_982# GND nfet_03v3 ad=0 pd=0 as=0.10566u ps=2.448m w=508 l=56
X2243 NAND3_6/m1_n3706_n1374# comp[55] NAND3_6/a_2506_982# GND nfet_03v3 ad=0 pd=0 as=0 ps=0 w=508 l=56
X2244 NAND3_6/a_2506_982# comp[55] NAND3_6/m1_n3706_n1374# GND nfet_03v3 ad=0 pd=0 as=0 ps=0 w=508 l=56
X2245 NAND3_6/a_2506_982# comp[55] NAND3_6/m1_n3706_n1374# GND nfet_03v3 ad=0 pd=0 as=0 ps=0 w=508 l=56
X2246 GND NAND3_6/a_2506_982# wl[56] GND nfet_03v3 ad=0 pd=0 as=0.10566u ps=2.448m w=508 l=56
X2247 GND NAND3_6/a_2506_982# wl[56] GND nfet_03v3 ad=0 pd=0 as=0 ps=0 w=508 l=56
X2248 wl[56] NAND3_6/a_2506_982# GND GND nfet_03v3 ad=0 pd=0 as=0 ps=0 w=508 l=56
X2249 wl[56] NAND3_6/a_2506_982# GND GND nfet_03v3 ad=0 pd=0 as=0 ps=0 w=508 l=56
X2250 VDD comp[47] NAND3_16/a_n593_982# VDD pfet_03v3 ad=0 pd=0 as=0.22308u ps=4.636m w=660 l=56
X2251 NAND3_16/a_n593_982# comp[47] VDD VDD pfet_03v3 ad=0 pd=0 as=0 ps=0 w=660 l=56
X2252 NAND3_16/a_n593_982# comp[47] VDD VDD pfet_03v3 ad=0 pd=0 as=0 ps=0 w=660 l=56
X2253 VDD comp[47] NAND3_16/a_n593_982# VDD pfet_03v3 ad=0 pd=0 as=0 ps=0 w=660 l=56
X2254 VDD comp[47] NAND3_16/a_n593_982# VDD pfet_03v3 ad=0 pd=0 as=0 ps=0 w=660 l=56
X2255 VDD comp[46] NAND3_16/a_2506_982# VDD pfet_03v3 ad=0 pd=0 as=0.66924u ps=0.01391 w=660 l=56
X2256 NAND3_16/a_2506_982# comp[46] VDD VDD pfet_03v3 ad=0 pd=0 as=0 ps=0 w=660 l=56
X2257 NAND3_16/a_2506_982# comp[46] VDD VDD pfet_03v3 ad=0 pd=0 as=0 ps=0 w=660 l=56
X2258 VDD comp[46] NAND3_16/a_2506_982# VDD pfet_03v3 ad=0 pd=0 as=0 ps=0 w=660 l=56
X2259 VDD comp[46] NAND3_16/a_2506_982# VDD pfet_03v3 ad=0 pd=0 as=0 ps=0 w=660 l=56
X2260 VDD comp[45] NAND3_16/a_2506_982# VDD pfet_03v3 ad=0 pd=0 as=0 ps=0 w=660 l=56
X2261 NAND3_16/a_2506_982# comp[45] VDD VDD pfet_03v3 ad=0 pd=0 as=0 ps=0 w=660 l=56
X2262 NAND3_16/a_2506_982# comp[45] VDD VDD pfet_03v3 ad=0 pd=0 as=0 ps=0 w=660 l=56
X2263 VDD comp[45] NAND3_16/a_2506_982# VDD pfet_03v3 ad=0 pd=0 as=0 ps=0 w=660 l=56
X2264 VDD comp[45] NAND3_16/a_2506_982# VDD pfet_03v3 ad=0 pd=0 as=0 ps=0 w=660 l=56
X2265 VDD NAND3_16/a_2506_982# wl[46] VDD pfet_03v3 ad=0 pd=0 as=0.22308u ps=4.636m w=660 l=56
X2266 wl[46] NAND3_16/a_2506_982# VDD VDD pfet_03v3 ad=0 pd=0 as=0 ps=0 w=660 l=56
X2267 wl[46] NAND3_16/a_2506_982# VDD VDD pfet_03v3 ad=0 pd=0 as=0 ps=0 w=660 l=56
X2268 VDD NAND3_16/a_2506_982# wl[46] VDD pfet_03v3 ad=0 pd=0 as=0 ps=0 w=660 l=56
X2269 VDD NAND3_16/a_2506_982# wl[46] VDD pfet_03v3 ad=0 pd=0 as=0 ps=0 w=660 l=56
X2270 VDD NAND3_16/a_n593_982# NAND3_16/a_2506_982# VDD pfet_03v3 ad=0 pd=0 as=0 ps=0 w=660 l=56
X2271 NAND3_16/a_2506_982# NAND3_16/a_n593_982# VDD VDD pfet_03v3 ad=0 pd=0 as=0 ps=0 w=660 l=56
X2272 NAND3_16/a_2506_982# NAND3_16/a_n593_982# VDD VDD pfet_03v3 ad=0 pd=0 as=0 ps=0 w=660 l=56
X2273 VDD NAND3_16/a_n593_982# NAND3_16/a_2506_982# VDD pfet_03v3 ad=0 pd=0 as=0 ps=0 w=660 l=56
X2274 VDD NAND3_16/a_n593_982# NAND3_16/a_2506_982# VDD pfet_03v3 ad=0 pd=0 as=0 ps=0 w=660 l=56
X2275 NAND3_16/m1_n2243_n1314# comp[46] NAND3_16/m1_n3706_n1374# GND nfet_03v3 ad=0.28245u pd=6.192m as=0.28245u ps=6.192m w=508 l=56
X2276 NAND3_16/m1_n2243_n1314# comp[46] NAND3_16/m1_n3706_n1374# GND nfet_03v3 ad=0 pd=0 as=0 ps=0 w=508 l=56
X2277 NAND3_16/m1_n3706_n1374# comp[46] NAND3_16/m1_n2243_n1314# GND nfet_03v3 ad=0 pd=0 as=0 ps=0 w=508 l=56
X2278 NAND3_16/m1_n3706_n1374# comp[46] NAND3_16/m1_n2243_n1314# GND nfet_03v3 ad=0 pd=0 as=0 ps=0 w=508 l=56
X2279 GND comp[47] NAND3_16/a_n593_982# GND nfet_03v3 ad=0 pd=0 as=0.10566u ps=2.448m w=508 l=56
X2280 GND comp[47] NAND3_16/a_n593_982# GND nfet_03v3 ad=0 pd=0 as=0 ps=0 w=508 l=56
X2281 NAND3_16/a_n593_982# comp[47] GND GND nfet_03v3 ad=0 pd=0 as=0 ps=0 w=508 l=56
X2282 NAND3_16/a_n593_982# comp[47] GND GND nfet_03v3 ad=0 pd=0 as=0 ps=0 w=508 l=56
X2283 GND NAND3_16/a_n593_982# NAND3_16/m1_n2243_n1314# GND nfet_03v3 ad=0 pd=0 as=0 ps=0 w=508 l=56
X2284 GND NAND3_16/a_n593_982# NAND3_16/m1_n2243_n1314# GND nfet_03v3 ad=0 pd=0 as=0 ps=0 w=508 l=56
X2285 NAND3_16/m1_n2243_n1314# NAND3_16/a_n593_982# GND GND nfet_03v3 ad=0 pd=0 as=0 ps=0 w=508 l=56
X2286 NAND3_16/m1_n2243_n1314# NAND3_16/a_n593_982# GND GND nfet_03v3 ad=0 pd=0 as=0 ps=0 w=508 l=56
X2287 NAND3_16/m1_n3706_n1374# comp[45] NAND3_16/a_2506_982# GND nfet_03v3 ad=0 pd=0 as=0.10566u ps=2.448m w=508 l=56
X2288 NAND3_16/m1_n3706_n1374# comp[45] NAND3_16/a_2506_982# GND nfet_03v3 ad=0 pd=0 as=0 ps=0 w=508 l=56
X2289 NAND3_16/a_2506_982# comp[45] NAND3_16/m1_n3706_n1374# GND nfet_03v3 ad=0 pd=0 as=0 ps=0 w=508 l=56
X2290 NAND3_16/a_2506_982# comp[45] NAND3_16/m1_n3706_n1374# GND nfet_03v3 ad=0 pd=0 as=0 ps=0 w=508 l=56
X2291 GND NAND3_16/a_2506_982# wl[46] GND nfet_03v3 ad=0 pd=0 as=0.10566u ps=2.448m w=508 l=56
X2292 GND NAND3_16/a_2506_982# wl[46] GND nfet_03v3 ad=0 pd=0 as=0 ps=0 w=508 l=56
X2293 wl[46] NAND3_16/a_2506_982# GND GND nfet_03v3 ad=0 pd=0 as=0 ps=0 w=508 l=56
X2294 wl[46] NAND3_16/a_2506_982# GND GND nfet_03v3 ad=0 pd=0 as=0 ps=0 w=508 l=56
X2295 VDD comp[36] NAND3_27/a_n593_982# VDD pfet_03v3 ad=0 pd=0 as=0.22308u ps=4.636m w=660 l=56
X2296 NAND3_27/a_n593_982# comp[36] VDD VDD pfet_03v3 ad=0 pd=0 as=0 ps=0 w=660 l=56
X2297 NAND3_27/a_n593_982# comp[36] VDD VDD pfet_03v3 ad=0 pd=0 as=0 ps=0 w=660 l=56
X2298 VDD comp[36] NAND3_27/a_n593_982# VDD pfet_03v3 ad=0 pd=0 as=0 ps=0 w=660 l=56
X2299 VDD comp[36] NAND3_27/a_n593_982# VDD pfet_03v3 ad=0 pd=0 as=0 ps=0 w=660 l=56
X2300 VDD comp[35] NAND3_27/a_2506_982# VDD pfet_03v3 ad=0 pd=0 as=0.66924u ps=0.01391 w=660 l=56
X2301 NAND3_27/a_2506_982# comp[35] VDD VDD pfet_03v3 ad=0 pd=0 as=0 ps=0 w=660 l=56
X2302 NAND3_27/a_2506_982# comp[35] VDD VDD pfet_03v3 ad=0 pd=0 as=0 ps=0 w=660 l=56
X2303 VDD comp[35] NAND3_27/a_2506_982# VDD pfet_03v3 ad=0 pd=0 as=0 ps=0 w=660 l=56
X2304 VDD comp[35] NAND3_27/a_2506_982# VDD pfet_03v3 ad=0 pd=0 as=0 ps=0 w=660 l=56
X2305 VDD comp[34] NAND3_27/a_2506_982# VDD pfet_03v3 ad=0 pd=0 as=0 ps=0 w=660 l=56
X2306 NAND3_27/a_2506_982# comp[34] VDD VDD pfet_03v3 ad=0 pd=0 as=0 ps=0 w=660 l=56
X2307 NAND3_27/a_2506_982# comp[34] VDD VDD pfet_03v3 ad=0 pd=0 as=0 ps=0 w=660 l=56
X2308 VDD comp[34] NAND3_27/a_2506_982# VDD pfet_03v3 ad=0 pd=0 as=0 ps=0 w=660 l=56
X2309 VDD comp[34] NAND3_27/a_2506_982# VDD pfet_03v3 ad=0 pd=0 as=0 ps=0 w=660 l=56
X2310 VDD NAND3_27/a_2506_982# wl[35] VDD pfet_03v3 ad=0 pd=0 as=0.22308u ps=4.636m w=660 l=56
X2311 wl[35] NAND3_27/a_2506_982# VDD VDD pfet_03v3 ad=0 pd=0 as=0 ps=0 w=660 l=56
X2312 wl[35] NAND3_27/a_2506_982# VDD VDD pfet_03v3 ad=0 pd=0 as=0 ps=0 w=660 l=56
X2313 VDD NAND3_27/a_2506_982# wl[35] VDD pfet_03v3 ad=0 pd=0 as=0 ps=0 w=660 l=56
X2314 VDD NAND3_27/a_2506_982# wl[35] VDD pfet_03v3 ad=0 pd=0 as=0 ps=0 w=660 l=56
X2315 VDD NAND3_27/a_n593_982# NAND3_27/a_2506_982# VDD pfet_03v3 ad=0 pd=0 as=0 ps=0 w=660 l=56
X2316 NAND3_27/a_2506_982# NAND3_27/a_n593_982# VDD VDD pfet_03v3 ad=0 pd=0 as=0 ps=0 w=660 l=56
X2317 NAND3_27/a_2506_982# NAND3_27/a_n593_982# VDD VDD pfet_03v3 ad=0 pd=0 as=0 ps=0 w=660 l=56
X2318 VDD NAND3_27/a_n593_982# NAND3_27/a_2506_982# VDD pfet_03v3 ad=0 pd=0 as=0 ps=0 w=660 l=56
X2319 VDD NAND3_27/a_n593_982# NAND3_27/a_2506_982# VDD pfet_03v3 ad=0 pd=0 as=0 ps=0 w=660 l=56
X2320 NAND3_27/m1_n2243_n1314# comp[35] NAND3_27/m1_n3706_n1374# GND nfet_03v3 ad=0.28245u pd=6.192m as=0.28245u ps=6.192m w=508 l=56
X2321 NAND3_27/m1_n2243_n1314# comp[35] NAND3_27/m1_n3706_n1374# GND nfet_03v3 ad=0 pd=0 as=0 ps=0 w=508 l=56
X2322 NAND3_27/m1_n3706_n1374# comp[35] NAND3_27/m1_n2243_n1314# GND nfet_03v3 ad=0 pd=0 as=0 ps=0 w=508 l=56
X2323 NAND3_27/m1_n3706_n1374# comp[35] NAND3_27/m1_n2243_n1314# GND nfet_03v3 ad=0 pd=0 as=0 ps=0 w=508 l=56
X2324 GND comp[36] NAND3_27/a_n593_982# GND nfet_03v3 ad=0 pd=0 as=0.10566u ps=2.448m w=508 l=56
X2325 GND comp[36] NAND3_27/a_n593_982# GND nfet_03v3 ad=0 pd=0 as=0 ps=0 w=508 l=56
X2326 NAND3_27/a_n593_982# comp[36] GND GND nfet_03v3 ad=0 pd=0 as=0 ps=0 w=508 l=56
X2327 NAND3_27/a_n593_982# comp[36] GND GND nfet_03v3 ad=0 pd=0 as=0 ps=0 w=508 l=56
X2328 GND NAND3_27/a_n593_982# NAND3_27/m1_n2243_n1314# GND nfet_03v3 ad=0 pd=0 as=0 ps=0 w=508 l=56
X2329 GND NAND3_27/a_n593_982# NAND3_27/m1_n2243_n1314# GND nfet_03v3 ad=0 pd=0 as=0 ps=0 w=508 l=56
X2330 NAND3_27/m1_n2243_n1314# NAND3_27/a_n593_982# GND GND nfet_03v3 ad=0 pd=0 as=0 ps=0 w=508 l=56
X2331 NAND3_27/m1_n2243_n1314# NAND3_27/a_n593_982# GND GND nfet_03v3 ad=0 pd=0 as=0 ps=0 w=508 l=56
X2332 NAND3_27/m1_n3706_n1374# comp[34] NAND3_27/a_2506_982# GND nfet_03v3 ad=0 pd=0 as=0.10566u ps=2.448m w=508 l=56
X2333 NAND3_27/m1_n3706_n1374# comp[34] NAND3_27/a_2506_982# GND nfet_03v3 ad=0 pd=0 as=0 ps=0 w=508 l=56
X2334 NAND3_27/a_2506_982# comp[34] NAND3_27/m1_n3706_n1374# GND nfet_03v3 ad=0 pd=0 as=0 ps=0 w=508 l=56
X2335 NAND3_27/a_2506_982# comp[34] NAND3_27/m1_n3706_n1374# GND nfet_03v3 ad=0 pd=0 as=0 ps=0 w=508 l=56
X2336 GND NAND3_27/a_2506_982# wl[35] GND nfet_03v3 ad=0 pd=0 as=0.10566u ps=2.448m w=508 l=56
X2337 GND NAND3_27/a_2506_982# wl[35] GND nfet_03v3 ad=0 pd=0 as=0 ps=0 w=508 l=56
X2338 wl[35] NAND3_27/a_2506_982# GND GND nfet_03v3 ad=0 pd=0 as=0 ps=0 w=508 l=56
X2339 wl[35] NAND3_27/a_2506_982# GND GND nfet_03v3 ad=0 pd=0 as=0 ps=0 w=508 l=56
X2340 VDD comp[25] NAND3_38/a_n593_982# VDD pfet_03v3 ad=0 pd=0 as=0.22308u ps=4.636m w=660 l=56
X2341 NAND3_38/a_n593_982# comp[25] VDD VDD pfet_03v3 ad=0 pd=0 as=0 ps=0 w=660 l=56
X2342 NAND3_38/a_n593_982# comp[25] VDD VDD pfet_03v3 ad=0 pd=0 as=0 ps=0 w=660 l=56
X2343 VDD comp[25] NAND3_38/a_n593_982# VDD pfet_03v3 ad=0 pd=0 as=0 ps=0 w=660 l=56
X2344 VDD comp[25] NAND3_38/a_n593_982# VDD pfet_03v3 ad=0 pd=0 as=0 ps=0 w=660 l=56
X2345 VDD comp[24] NAND3_38/a_2506_982# VDD pfet_03v3 ad=0 pd=0 as=0.66924u ps=0.01391 w=660 l=56
X2346 NAND3_38/a_2506_982# comp[24] VDD VDD pfet_03v3 ad=0 pd=0 as=0 ps=0 w=660 l=56
X2347 NAND3_38/a_2506_982# comp[24] VDD VDD pfet_03v3 ad=0 pd=0 as=0 ps=0 w=660 l=56
X2348 VDD comp[24] NAND3_38/a_2506_982# VDD pfet_03v3 ad=0 pd=0 as=0 ps=0 w=660 l=56
X2349 VDD comp[24] NAND3_38/a_2506_982# VDD pfet_03v3 ad=0 pd=0 as=0 ps=0 w=660 l=56
X2350 VDD comp[23] NAND3_38/a_2506_982# VDD pfet_03v3 ad=0 pd=0 as=0 ps=0 w=660 l=56
X2351 NAND3_38/a_2506_982# comp[23] VDD VDD pfet_03v3 ad=0 pd=0 as=0 ps=0 w=660 l=56
X2352 NAND3_38/a_2506_982# comp[23] VDD VDD pfet_03v3 ad=0 pd=0 as=0 ps=0 w=660 l=56
X2353 VDD comp[23] NAND3_38/a_2506_982# VDD pfet_03v3 ad=0 pd=0 as=0 ps=0 w=660 l=56
X2354 VDD comp[23] NAND3_38/a_2506_982# VDD pfet_03v3 ad=0 pd=0 as=0 ps=0 w=660 l=56
X2355 VDD NAND3_38/a_2506_982# wl[24] VDD pfet_03v3 ad=0 pd=0 as=0.22308u ps=4.636m w=660 l=56
X2356 wl[24] NAND3_38/a_2506_982# VDD VDD pfet_03v3 ad=0 pd=0 as=0 ps=0 w=660 l=56
X2357 wl[24] NAND3_38/a_2506_982# VDD VDD pfet_03v3 ad=0 pd=0 as=0 ps=0 w=660 l=56
X2358 VDD NAND3_38/a_2506_982# wl[24] VDD pfet_03v3 ad=0 pd=0 as=0 ps=0 w=660 l=56
X2359 VDD NAND3_38/a_2506_982# wl[24] VDD pfet_03v3 ad=0 pd=0 as=0 ps=0 w=660 l=56
X2360 VDD NAND3_38/a_n593_982# NAND3_38/a_2506_982# VDD pfet_03v3 ad=0 pd=0 as=0 ps=0 w=660 l=56
X2361 NAND3_38/a_2506_982# NAND3_38/a_n593_982# VDD VDD pfet_03v3 ad=0 pd=0 as=0 ps=0 w=660 l=56
X2362 NAND3_38/a_2506_982# NAND3_38/a_n593_982# VDD VDD pfet_03v3 ad=0 pd=0 as=0 ps=0 w=660 l=56
X2363 VDD NAND3_38/a_n593_982# NAND3_38/a_2506_982# VDD pfet_03v3 ad=0 pd=0 as=0 ps=0 w=660 l=56
X2364 VDD NAND3_38/a_n593_982# NAND3_38/a_2506_982# VDD pfet_03v3 ad=0 pd=0 as=0 ps=0 w=660 l=56
X2365 NAND3_38/m1_n2243_n1314# comp[24] NAND3_38/m1_n3706_n1374# GND nfet_03v3 ad=0.28245u pd=6.192m as=0.28245u ps=6.192m w=508 l=56
X2366 NAND3_38/m1_n2243_n1314# comp[24] NAND3_38/m1_n3706_n1374# GND nfet_03v3 ad=0 pd=0 as=0 ps=0 w=508 l=56
X2367 NAND3_38/m1_n3706_n1374# comp[24] NAND3_38/m1_n2243_n1314# GND nfet_03v3 ad=0 pd=0 as=0 ps=0 w=508 l=56
X2368 NAND3_38/m1_n3706_n1374# comp[24] NAND3_38/m1_n2243_n1314# GND nfet_03v3 ad=0 pd=0 as=0 ps=0 w=508 l=56
X2369 GND comp[25] NAND3_38/a_n593_982# GND nfet_03v3 ad=0 pd=0 as=0.10566u ps=2.448m w=508 l=56
X2370 GND comp[25] NAND3_38/a_n593_982# GND nfet_03v3 ad=0 pd=0 as=0 ps=0 w=508 l=56
X2371 NAND3_38/a_n593_982# comp[25] GND GND nfet_03v3 ad=0 pd=0 as=0 ps=0 w=508 l=56
X2372 NAND3_38/a_n593_982# comp[25] GND GND nfet_03v3 ad=0 pd=0 as=0 ps=0 w=508 l=56
X2373 GND NAND3_38/a_n593_982# NAND3_38/m1_n2243_n1314# GND nfet_03v3 ad=0 pd=0 as=0 ps=0 w=508 l=56
X2374 GND NAND3_38/a_n593_982# NAND3_38/m1_n2243_n1314# GND nfet_03v3 ad=0 pd=0 as=0 ps=0 w=508 l=56
X2375 NAND3_38/m1_n2243_n1314# NAND3_38/a_n593_982# GND GND nfet_03v3 ad=0 pd=0 as=0 ps=0 w=508 l=56
X2376 NAND3_38/m1_n2243_n1314# NAND3_38/a_n593_982# GND GND nfet_03v3 ad=0 pd=0 as=0 ps=0 w=508 l=56
X2377 NAND3_38/m1_n3706_n1374# comp[23] NAND3_38/a_2506_982# GND nfet_03v3 ad=0 pd=0 as=0.10566u ps=2.448m w=508 l=56
X2378 NAND3_38/m1_n3706_n1374# comp[23] NAND3_38/a_2506_982# GND nfet_03v3 ad=0 pd=0 as=0 ps=0 w=508 l=56
X2379 NAND3_38/a_2506_982# comp[23] NAND3_38/m1_n3706_n1374# GND nfet_03v3 ad=0 pd=0 as=0 ps=0 w=508 l=56
X2380 NAND3_38/a_2506_982# comp[23] NAND3_38/m1_n3706_n1374# GND nfet_03v3 ad=0 pd=0 as=0 ps=0 w=508 l=56
X2381 GND NAND3_38/a_2506_982# wl[24] GND nfet_03v3 ad=0 pd=0 as=0.10566u ps=2.448m w=508 l=56
X2382 GND NAND3_38/a_2506_982# wl[24] GND nfet_03v3 ad=0 pd=0 as=0 ps=0 w=508 l=56
X2383 wl[24] NAND3_38/a_2506_982# GND GND nfet_03v3 ad=0 pd=0 as=0 ps=0 w=508 l=56
X2384 wl[24] NAND3_38/a_2506_982# GND GND nfet_03v3 ad=0 pd=0 as=0 ps=0 w=508 l=56
X2385 VDD comp[14] NAND3_49/a_n593_982# VDD pfet_03v3 ad=0 pd=0 as=0.22308u ps=4.636m w=660 l=56
X2386 NAND3_49/a_n593_982# comp[14] VDD VDD pfet_03v3 ad=0 pd=0 as=0 ps=0 w=660 l=56
X2387 NAND3_49/a_n593_982# comp[14] VDD VDD pfet_03v3 ad=0 pd=0 as=0 ps=0 w=660 l=56
X2388 VDD comp[14] NAND3_49/a_n593_982# VDD pfet_03v3 ad=0 pd=0 as=0 ps=0 w=660 l=56
X2389 VDD comp[14] NAND3_49/a_n593_982# VDD pfet_03v3 ad=0 pd=0 as=0 ps=0 w=660 l=56
X2390 VDD comp[13] NAND3_49/a_2506_982# VDD pfet_03v3 ad=0 pd=0 as=0.66924u ps=0.01391 w=660 l=56
X2391 NAND3_49/a_2506_982# comp[13] VDD VDD pfet_03v3 ad=0 pd=0 as=0 ps=0 w=660 l=56
X2392 NAND3_49/a_2506_982# comp[13] VDD VDD pfet_03v3 ad=0 pd=0 as=0 ps=0 w=660 l=56
X2393 VDD comp[13] NAND3_49/a_2506_982# VDD pfet_03v3 ad=0 pd=0 as=0 ps=0 w=660 l=56
X2394 VDD comp[13] NAND3_49/a_2506_982# VDD pfet_03v3 ad=0 pd=0 as=0 ps=0 w=660 l=56
X2395 VDD comp[12] NAND3_49/a_2506_982# VDD pfet_03v3 ad=0 pd=0 as=0 ps=0 w=660 l=56
X2396 NAND3_49/a_2506_982# comp[12] VDD VDD pfet_03v3 ad=0 pd=0 as=0 ps=0 w=660 l=56
X2397 NAND3_49/a_2506_982# comp[12] VDD VDD pfet_03v3 ad=0 pd=0 as=0 ps=0 w=660 l=56
X2398 VDD comp[12] NAND3_49/a_2506_982# VDD pfet_03v3 ad=0 pd=0 as=0 ps=0 w=660 l=56
X2399 VDD comp[12] NAND3_49/a_2506_982# VDD pfet_03v3 ad=0 pd=0 as=0 ps=0 w=660 l=56
X2400 VDD NAND3_49/a_2506_982# wl[13] VDD pfet_03v3 ad=0 pd=0 as=0.22308u ps=4.636m w=660 l=56
X2401 wl[13] NAND3_49/a_2506_982# VDD VDD pfet_03v3 ad=0 pd=0 as=0 ps=0 w=660 l=56
X2402 wl[13] NAND3_49/a_2506_982# VDD VDD pfet_03v3 ad=0 pd=0 as=0 ps=0 w=660 l=56
X2403 VDD NAND3_49/a_2506_982# wl[13] VDD pfet_03v3 ad=0 pd=0 as=0 ps=0 w=660 l=56
X2404 VDD NAND3_49/a_2506_982# wl[13] VDD pfet_03v3 ad=0 pd=0 as=0 ps=0 w=660 l=56
X2405 VDD NAND3_49/a_n593_982# NAND3_49/a_2506_982# VDD pfet_03v3 ad=0 pd=0 as=0 ps=0 w=660 l=56
X2406 NAND3_49/a_2506_982# NAND3_49/a_n593_982# VDD VDD pfet_03v3 ad=0 pd=0 as=0 ps=0 w=660 l=56
X2407 NAND3_49/a_2506_982# NAND3_49/a_n593_982# VDD VDD pfet_03v3 ad=0 pd=0 as=0 ps=0 w=660 l=56
X2408 VDD NAND3_49/a_n593_982# NAND3_49/a_2506_982# VDD pfet_03v3 ad=0 pd=0 as=0 ps=0 w=660 l=56
X2409 VDD NAND3_49/a_n593_982# NAND3_49/a_2506_982# VDD pfet_03v3 ad=0 pd=0 as=0 ps=0 w=660 l=56
X2410 NAND3_49/m1_n2243_n1314# comp[13] NAND3_49/m1_n3706_n1374# GND nfet_03v3 ad=0.28245u pd=6.192m as=0.28245u ps=6.192m w=508 l=56
X2411 NAND3_49/m1_n2243_n1314# comp[13] NAND3_49/m1_n3706_n1374# GND nfet_03v3 ad=0 pd=0 as=0 ps=0 w=508 l=56
X2412 NAND3_49/m1_n3706_n1374# comp[13] NAND3_49/m1_n2243_n1314# GND nfet_03v3 ad=0 pd=0 as=0 ps=0 w=508 l=56
X2413 NAND3_49/m1_n3706_n1374# comp[13] NAND3_49/m1_n2243_n1314# GND nfet_03v3 ad=0 pd=0 as=0 ps=0 w=508 l=56
X2414 GND comp[14] NAND3_49/a_n593_982# GND nfet_03v3 ad=0 pd=0 as=0.10566u ps=2.448m w=508 l=56
X2415 GND comp[14] NAND3_49/a_n593_982# GND nfet_03v3 ad=0 pd=0 as=0 ps=0 w=508 l=56
X2416 NAND3_49/a_n593_982# comp[14] GND GND nfet_03v3 ad=0 pd=0 as=0 ps=0 w=508 l=56
X2417 NAND3_49/a_n593_982# comp[14] GND GND nfet_03v3 ad=0 pd=0 as=0 ps=0 w=508 l=56
X2418 GND NAND3_49/a_n593_982# NAND3_49/m1_n2243_n1314# GND nfet_03v3 ad=0 pd=0 as=0 ps=0 w=508 l=56
X2419 GND NAND3_49/a_n593_982# NAND3_49/m1_n2243_n1314# GND nfet_03v3 ad=0 pd=0 as=0 ps=0 w=508 l=56
X2420 NAND3_49/m1_n2243_n1314# NAND3_49/a_n593_982# GND GND nfet_03v3 ad=0 pd=0 as=0 ps=0 w=508 l=56
X2421 NAND3_49/m1_n2243_n1314# NAND3_49/a_n593_982# GND GND nfet_03v3 ad=0 pd=0 as=0 ps=0 w=508 l=56
X2422 NAND3_49/m1_n3706_n1374# comp[12] NAND3_49/a_2506_982# GND nfet_03v3 ad=0 pd=0 as=0.10566u ps=2.448m w=508 l=56
X2423 NAND3_49/m1_n3706_n1374# comp[12] NAND3_49/a_2506_982# GND nfet_03v3 ad=0 pd=0 as=0 ps=0 w=508 l=56
X2424 NAND3_49/a_2506_982# comp[12] NAND3_49/m1_n3706_n1374# GND nfet_03v3 ad=0 pd=0 as=0 ps=0 w=508 l=56
X2425 NAND3_49/a_2506_982# comp[12] NAND3_49/m1_n3706_n1374# GND nfet_03v3 ad=0 pd=0 as=0 ps=0 w=508 l=56
X2426 GND NAND3_49/a_2506_982# wl[13] GND nfet_03v3 ad=0 pd=0 as=0.10566u ps=2.448m w=508 l=56
X2427 GND NAND3_49/a_2506_982# wl[13] GND nfet_03v3 ad=0 pd=0 as=0 ps=0 w=508 l=56
X2428 wl[13] NAND3_49/a_2506_982# GND GND nfet_03v3 ad=0 pd=0 as=0 ps=0 w=508 l=56
X2429 wl[13] NAND3_49/a_2506_982# GND GND nfet_03v3 ad=0 pd=0 as=0 ps=0 w=508 l=56
X2430 VDD comp[56] NAND3_7/a_n593_982# VDD pfet_03v3 ad=0 pd=0 as=0.22308u ps=4.636m w=660 l=56
X2431 NAND3_7/a_n593_982# comp[56] VDD VDD pfet_03v3 ad=0 pd=0 as=0 ps=0 w=660 l=56
X2432 NAND3_7/a_n593_982# comp[56] VDD VDD pfet_03v3 ad=0 pd=0 as=0 ps=0 w=660 l=56
X2433 VDD comp[56] NAND3_7/a_n593_982# VDD pfet_03v3 ad=0 pd=0 as=0 ps=0 w=660 l=56
X2434 VDD comp[56] NAND3_7/a_n593_982# VDD pfet_03v3 ad=0 pd=0 as=0 ps=0 w=660 l=56
X2435 VDD comp[55] NAND3_7/a_2506_982# VDD pfet_03v3 ad=0 pd=0 as=0.66924u ps=0.01391 w=660 l=56
X2436 NAND3_7/a_2506_982# comp[55] VDD VDD pfet_03v3 ad=0 pd=0 as=0 ps=0 w=660 l=56
X2437 NAND3_7/a_2506_982# comp[55] VDD VDD pfet_03v3 ad=0 pd=0 as=0 ps=0 w=660 l=56
X2438 VDD comp[55] NAND3_7/a_2506_982# VDD pfet_03v3 ad=0 pd=0 as=0 ps=0 w=660 l=56
X2439 VDD comp[55] NAND3_7/a_2506_982# VDD pfet_03v3 ad=0 pd=0 as=0 ps=0 w=660 l=56
X2440 VDD comp[54] NAND3_7/a_2506_982# VDD pfet_03v3 ad=0 pd=0 as=0 ps=0 w=660 l=56
X2441 NAND3_7/a_2506_982# comp[54] VDD VDD pfet_03v3 ad=0 pd=0 as=0 ps=0 w=660 l=56
X2442 NAND3_7/a_2506_982# comp[54] VDD VDD pfet_03v3 ad=0 pd=0 as=0 ps=0 w=660 l=56
X2443 VDD comp[54] NAND3_7/a_2506_982# VDD pfet_03v3 ad=0 pd=0 as=0 ps=0 w=660 l=56
X2444 VDD comp[54] NAND3_7/a_2506_982# VDD pfet_03v3 ad=0 pd=0 as=0 ps=0 w=660 l=56
X2445 VDD NAND3_7/a_2506_982# wl[55] VDD pfet_03v3 ad=0 pd=0 as=0.22308u ps=4.636m w=660 l=56
X2446 wl[55] NAND3_7/a_2506_982# VDD VDD pfet_03v3 ad=0 pd=0 as=0 ps=0 w=660 l=56
X2447 wl[55] NAND3_7/a_2506_982# VDD VDD pfet_03v3 ad=0 pd=0 as=0 ps=0 w=660 l=56
X2448 VDD NAND3_7/a_2506_982# wl[55] VDD pfet_03v3 ad=0 pd=0 as=0 ps=0 w=660 l=56
X2449 VDD NAND3_7/a_2506_982# wl[55] VDD pfet_03v3 ad=0 pd=0 as=0 ps=0 w=660 l=56
X2450 VDD NAND3_7/a_n593_982# NAND3_7/a_2506_982# VDD pfet_03v3 ad=0 pd=0 as=0 ps=0 w=660 l=56
X2451 NAND3_7/a_2506_982# NAND3_7/a_n593_982# VDD VDD pfet_03v3 ad=0 pd=0 as=0 ps=0 w=660 l=56
X2452 NAND3_7/a_2506_982# NAND3_7/a_n593_982# VDD VDD pfet_03v3 ad=0 pd=0 as=0 ps=0 w=660 l=56
X2453 VDD NAND3_7/a_n593_982# NAND3_7/a_2506_982# VDD pfet_03v3 ad=0 pd=0 as=0 ps=0 w=660 l=56
X2454 VDD NAND3_7/a_n593_982# NAND3_7/a_2506_982# VDD pfet_03v3 ad=0 pd=0 as=0 ps=0 w=660 l=56
X2455 NAND3_7/m1_n2243_n1314# comp[55] NAND3_7/m1_n3706_n1374# GND nfet_03v3 ad=0.28245u pd=6.192m as=0.28245u ps=6.192m w=508 l=56
X2456 NAND3_7/m1_n2243_n1314# comp[55] NAND3_7/m1_n3706_n1374# GND nfet_03v3 ad=0 pd=0 as=0 ps=0 w=508 l=56
X2457 NAND3_7/m1_n3706_n1374# comp[55] NAND3_7/m1_n2243_n1314# GND nfet_03v3 ad=0 pd=0 as=0 ps=0 w=508 l=56
X2458 NAND3_7/m1_n3706_n1374# comp[55] NAND3_7/m1_n2243_n1314# GND nfet_03v3 ad=0 pd=0 as=0 ps=0 w=508 l=56
X2459 GND comp[56] NAND3_7/a_n593_982# GND nfet_03v3 ad=0 pd=0 as=0.10566u ps=2.448m w=508 l=56
X2460 GND comp[56] NAND3_7/a_n593_982# GND nfet_03v3 ad=0 pd=0 as=0 ps=0 w=508 l=56
X2461 NAND3_7/a_n593_982# comp[56] GND GND nfet_03v3 ad=0 pd=0 as=0 ps=0 w=508 l=56
X2462 NAND3_7/a_n593_982# comp[56] GND GND nfet_03v3 ad=0 pd=0 as=0 ps=0 w=508 l=56
X2463 GND NAND3_7/a_n593_982# NAND3_7/m1_n2243_n1314# GND nfet_03v3 ad=0 pd=0 as=0 ps=0 w=508 l=56
X2464 GND NAND3_7/a_n593_982# NAND3_7/m1_n2243_n1314# GND nfet_03v3 ad=0 pd=0 as=0 ps=0 w=508 l=56
X2465 NAND3_7/m1_n2243_n1314# NAND3_7/a_n593_982# GND GND nfet_03v3 ad=0 pd=0 as=0 ps=0 w=508 l=56
X2466 NAND3_7/m1_n2243_n1314# NAND3_7/a_n593_982# GND GND nfet_03v3 ad=0 pd=0 as=0 ps=0 w=508 l=56
X2467 NAND3_7/m1_n3706_n1374# comp[54] NAND3_7/a_2506_982# GND nfet_03v3 ad=0 pd=0 as=0.10566u ps=2.448m w=508 l=56
X2468 NAND3_7/m1_n3706_n1374# comp[54] NAND3_7/a_2506_982# GND nfet_03v3 ad=0 pd=0 as=0 ps=0 w=508 l=56
X2469 NAND3_7/a_2506_982# comp[54] NAND3_7/m1_n3706_n1374# GND nfet_03v3 ad=0 pd=0 as=0 ps=0 w=508 l=56
X2470 NAND3_7/a_2506_982# comp[54] NAND3_7/m1_n3706_n1374# GND nfet_03v3 ad=0 pd=0 as=0 ps=0 w=508 l=56
X2471 GND NAND3_7/a_2506_982# wl[55] GND nfet_03v3 ad=0 pd=0 as=0.10566u ps=2.448m w=508 l=56
X2472 GND NAND3_7/a_2506_982# wl[55] GND nfet_03v3 ad=0 pd=0 as=0 ps=0 w=508 l=56
X2473 wl[55] NAND3_7/a_2506_982# GND GND nfet_03v3 ad=0 pd=0 as=0 ps=0 w=508 l=56
X2474 wl[55] NAND3_7/a_2506_982# GND GND nfet_03v3 ad=0 pd=0 as=0 ps=0 w=508 l=56
X2475 VDD comp[46] NAND3_17/a_n593_982# VDD pfet_03v3 ad=0 pd=0 as=0.22308u ps=4.636m w=660 l=56
X2476 NAND3_17/a_n593_982# comp[46] VDD VDD pfet_03v3 ad=0 pd=0 as=0 ps=0 w=660 l=56
X2477 NAND3_17/a_n593_982# comp[46] VDD VDD pfet_03v3 ad=0 pd=0 as=0 ps=0 w=660 l=56
X2478 VDD comp[46] NAND3_17/a_n593_982# VDD pfet_03v3 ad=0 pd=0 as=0 ps=0 w=660 l=56
X2479 VDD comp[46] NAND3_17/a_n593_982# VDD pfet_03v3 ad=0 pd=0 as=0 ps=0 w=660 l=56
X2480 VDD comp[45] NAND3_17/a_2506_982# VDD pfet_03v3 ad=0 pd=0 as=0.66924u ps=0.01391 w=660 l=56
X2481 NAND3_17/a_2506_982# comp[45] VDD VDD pfet_03v3 ad=0 pd=0 as=0 ps=0 w=660 l=56
X2482 NAND3_17/a_2506_982# comp[45] VDD VDD pfet_03v3 ad=0 pd=0 as=0 ps=0 w=660 l=56
X2483 VDD comp[45] NAND3_17/a_2506_982# VDD pfet_03v3 ad=0 pd=0 as=0 ps=0 w=660 l=56
X2484 VDD comp[45] NAND3_17/a_2506_982# VDD pfet_03v3 ad=0 pd=0 as=0 ps=0 w=660 l=56
X2485 VDD comp[44] NAND3_17/a_2506_982# VDD pfet_03v3 ad=0 pd=0 as=0 ps=0 w=660 l=56
X2486 NAND3_17/a_2506_982# comp[44] VDD VDD pfet_03v3 ad=0 pd=0 as=0 ps=0 w=660 l=56
X2487 NAND3_17/a_2506_982# comp[44] VDD VDD pfet_03v3 ad=0 pd=0 as=0 ps=0 w=660 l=56
X2488 VDD comp[44] NAND3_17/a_2506_982# VDD pfet_03v3 ad=0 pd=0 as=0 ps=0 w=660 l=56
X2489 VDD comp[44] NAND3_17/a_2506_982# VDD pfet_03v3 ad=0 pd=0 as=0 ps=0 w=660 l=56
X2490 VDD NAND3_17/a_2506_982# wl[45] VDD pfet_03v3 ad=0 pd=0 as=0.22308u ps=4.636m w=660 l=56
X2491 wl[45] NAND3_17/a_2506_982# VDD VDD pfet_03v3 ad=0 pd=0 as=0 ps=0 w=660 l=56
X2492 wl[45] NAND3_17/a_2506_982# VDD VDD pfet_03v3 ad=0 pd=0 as=0 ps=0 w=660 l=56
X2493 VDD NAND3_17/a_2506_982# wl[45] VDD pfet_03v3 ad=0 pd=0 as=0 ps=0 w=660 l=56
X2494 VDD NAND3_17/a_2506_982# wl[45] VDD pfet_03v3 ad=0 pd=0 as=0 ps=0 w=660 l=56
X2495 VDD NAND3_17/a_n593_982# NAND3_17/a_2506_982# VDD pfet_03v3 ad=0 pd=0 as=0 ps=0 w=660 l=56
X2496 NAND3_17/a_2506_982# NAND3_17/a_n593_982# VDD VDD pfet_03v3 ad=0 pd=0 as=0 ps=0 w=660 l=56
X2497 NAND3_17/a_2506_982# NAND3_17/a_n593_982# VDD VDD pfet_03v3 ad=0 pd=0 as=0 ps=0 w=660 l=56
X2498 VDD NAND3_17/a_n593_982# NAND3_17/a_2506_982# VDD pfet_03v3 ad=0 pd=0 as=0 ps=0 w=660 l=56
X2499 VDD NAND3_17/a_n593_982# NAND3_17/a_2506_982# VDD pfet_03v3 ad=0 pd=0 as=0 ps=0 w=660 l=56
X2500 NAND3_17/m1_n2243_n1314# comp[45] NAND3_17/m1_n3706_n1374# GND nfet_03v3 ad=0.28245u pd=6.192m as=0.28245u ps=6.192m w=508 l=56
X2501 NAND3_17/m1_n2243_n1314# comp[45] NAND3_17/m1_n3706_n1374# GND nfet_03v3 ad=0 pd=0 as=0 ps=0 w=508 l=56
X2502 NAND3_17/m1_n3706_n1374# comp[45] NAND3_17/m1_n2243_n1314# GND nfet_03v3 ad=0 pd=0 as=0 ps=0 w=508 l=56
X2503 NAND3_17/m1_n3706_n1374# comp[45] NAND3_17/m1_n2243_n1314# GND nfet_03v3 ad=0 pd=0 as=0 ps=0 w=508 l=56
X2504 GND comp[46] NAND3_17/a_n593_982# GND nfet_03v3 ad=0 pd=0 as=0.10566u ps=2.448m w=508 l=56
X2505 GND comp[46] NAND3_17/a_n593_982# GND nfet_03v3 ad=0 pd=0 as=0 ps=0 w=508 l=56
X2506 NAND3_17/a_n593_982# comp[46] GND GND nfet_03v3 ad=0 pd=0 as=0 ps=0 w=508 l=56
X2507 NAND3_17/a_n593_982# comp[46] GND GND nfet_03v3 ad=0 pd=0 as=0 ps=0 w=508 l=56
X2508 GND NAND3_17/a_n593_982# NAND3_17/m1_n2243_n1314# GND nfet_03v3 ad=0 pd=0 as=0 ps=0 w=508 l=56
X2509 GND NAND3_17/a_n593_982# NAND3_17/m1_n2243_n1314# GND nfet_03v3 ad=0 pd=0 as=0 ps=0 w=508 l=56
X2510 NAND3_17/m1_n2243_n1314# NAND3_17/a_n593_982# GND GND nfet_03v3 ad=0 pd=0 as=0 ps=0 w=508 l=56
X2511 NAND3_17/m1_n2243_n1314# NAND3_17/a_n593_982# GND GND nfet_03v3 ad=0 pd=0 as=0 ps=0 w=508 l=56
X2512 NAND3_17/m1_n3706_n1374# comp[44] NAND3_17/a_2506_982# GND nfet_03v3 ad=0 pd=0 as=0.10566u ps=2.448m w=508 l=56
X2513 NAND3_17/m1_n3706_n1374# comp[44] NAND3_17/a_2506_982# GND nfet_03v3 ad=0 pd=0 as=0 ps=0 w=508 l=56
X2514 NAND3_17/a_2506_982# comp[44] NAND3_17/m1_n3706_n1374# GND nfet_03v3 ad=0 pd=0 as=0 ps=0 w=508 l=56
X2515 NAND3_17/a_2506_982# comp[44] NAND3_17/m1_n3706_n1374# GND nfet_03v3 ad=0 pd=0 as=0 ps=0 w=508 l=56
X2516 GND NAND3_17/a_2506_982# wl[45] GND nfet_03v3 ad=0 pd=0 as=0.10566u ps=2.448m w=508 l=56
X2517 GND NAND3_17/a_2506_982# wl[45] GND nfet_03v3 ad=0 pd=0 as=0 ps=0 w=508 l=56
X2518 wl[45] NAND3_17/a_2506_982# GND GND nfet_03v3 ad=0 pd=0 as=0 ps=0 w=508 l=56
X2519 wl[45] NAND3_17/a_2506_982# GND GND nfet_03v3 ad=0 pd=0 as=0 ps=0 w=508 l=56
X2520 VDD comp[35] NAND3_28/a_n593_982# VDD pfet_03v3 ad=0 pd=0 as=0.22308u ps=4.636m w=660 l=56
X2521 NAND3_28/a_n593_982# comp[35] VDD VDD pfet_03v3 ad=0 pd=0 as=0 ps=0 w=660 l=56
X2522 NAND3_28/a_n593_982# comp[35] VDD VDD pfet_03v3 ad=0 pd=0 as=0 ps=0 w=660 l=56
X2523 VDD comp[35] NAND3_28/a_n593_982# VDD pfet_03v3 ad=0 pd=0 as=0 ps=0 w=660 l=56
X2524 VDD comp[35] NAND3_28/a_n593_982# VDD pfet_03v3 ad=0 pd=0 as=0 ps=0 w=660 l=56
X2525 VDD comp[34] NAND3_28/a_2506_982# VDD pfet_03v3 ad=0 pd=0 as=0.66924u ps=0.01391 w=660 l=56
X2526 NAND3_28/a_2506_982# comp[34] VDD VDD pfet_03v3 ad=0 pd=0 as=0 ps=0 w=660 l=56
X2527 NAND3_28/a_2506_982# comp[34] VDD VDD pfet_03v3 ad=0 pd=0 as=0 ps=0 w=660 l=56
X2528 VDD comp[34] NAND3_28/a_2506_982# VDD pfet_03v3 ad=0 pd=0 as=0 ps=0 w=660 l=56
X2529 VDD comp[34] NAND3_28/a_2506_982# VDD pfet_03v3 ad=0 pd=0 as=0 ps=0 w=660 l=56
X2530 VDD comp[33] NAND3_28/a_2506_982# VDD pfet_03v3 ad=0 pd=0 as=0 ps=0 w=660 l=56
X2531 NAND3_28/a_2506_982# comp[33] VDD VDD pfet_03v3 ad=0 pd=0 as=0 ps=0 w=660 l=56
X2532 NAND3_28/a_2506_982# comp[33] VDD VDD pfet_03v3 ad=0 pd=0 as=0 ps=0 w=660 l=56
X2533 VDD comp[33] NAND3_28/a_2506_982# VDD pfet_03v3 ad=0 pd=0 as=0 ps=0 w=660 l=56
X2534 VDD comp[33] NAND3_28/a_2506_982# VDD pfet_03v3 ad=0 pd=0 as=0 ps=0 w=660 l=56
X2535 VDD NAND3_28/a_2506_982# wl[34] VDD pfet_03v3 ad=0 pd=0 as=0.22308u ps=4.636m w=660 l=56
X2536 wl[34] NAND3_28/a_2506_982# VDD VDD pfet_03v3 ad=0 pd=0 as=0 ps=0 w=660 l=56
X2537 wl[34] NAND3_28/a_2506_982# VDD VDD pfet_03v3 ad=0 pd=0 as=0 ps=0 w=660 l=56
X2538 VDD NAND3_28/a_2506_982# wl[34] VDD pfet_03v3 ad=0 pd=0 as=0 ps=0 w=660 l=56
X2539 VDD NAND3_28/a_2506_982# wl[34] VDD pfet_03v3 ad=0 pd=0 as=0 ps=0 w=660 l=56
X2540 VDD NAND3_28/a_n593_982# NAND3_28/a_2506_982# VDD pfet_03v3 ad=0 pd=0 as=0 ps=0 w=660 l=56
X2541 NAND3_28/a_2506_982# NAND3_28/a_n593_982# VDD VDD pfet_03v3 ad=0 pd=0 as=0 ps=0 w=660 l=56
X2542 NAND3_28/a_2506_982# NAND3_28/a_n593_982# VDD VDD pfet_03v3 ad=0 pd=0 as=0 ps=0 w=660 l=56
X2543 VDD NAND3_28/a_n593_982# NAND3_28/a_2506_982# VDD pfet_03v3 ad=0 pd=0 as=0 ps=0 w=660 l=56
X2544 VDD NAND3_28/a_n593_982# NAND3_28/a_2506_982# VDD pfet_03v3 ad=0 pd=0 as=0 ps=0 w=660 l=56
X2545 NAND3_28/m1_n2243_n1314# comp[34] NAND3_28/m1_n3706_n1374# GND nfet_03v3 ad=0.28245u pd=6.192m as=0.28245u ps=6.192m w=508 l=56
X2546 NAND3_28/m1_n2243_n1314# comp[34] NAND3_28/m1_n3706_n1374# GND nfet_03v3 ad=0 pd=0 as=0 ps=0 w=508 l=56
X2547 NAND3_28/m1_n3706_n1374# comp[34] NAND3_28/m1_n2243_n1314# GND nfet_03v3 ad=0 pd=0 as=0 ps=0 w=508 l=56
X2548 NAND3_28/m1_n3706_n1374# comp[34] NAND3_28/m1_n2243_n1314# GND nfet_03v3 ad=0 pd=0 as=0 ps=0 w=508 l=56
X2549 GND comp[35] NAND3_28/a_n593_982# GND nfet_03v3 ad=0 pd=0 as=0.10566u ps=2.448m w=508 l=56
X2550 GND comp[35] NAND3_28/a_n593_982# GND nfet_03v3 ad=0 pd=0 as=0 ps=0 w=508 l=56
X2551 NAND3_28/a_n593_982# comp[35] GND GND nfet_03v3 ad=0 pd=0 as=0 ps=0 w=508 l=56
X2552 NAND3_28/a_n593_982# comp[35] GND GND nfet_03v3 ad=0 pd=0 as=0 ps=0 w=508 l=56
X2553 GND NAND3_28/a_n593_982# NAND3_28/m1_n2243_n1314# GND nfet_03v3 ad=0 pd=0 as=0 ps=0 w=508 l=56
X2554 GND NAND3_28/a_n593_982# NAND3_28/m1_n2243_n1314# GND nfet_03v3 ad=0 pd=0 as=0 ps=0 w=508 l=56
X2555 NAND3_28/m1_n2243_n1314# NAND3_28/a_n593_982# GND GND nfet_03v3 ad=0 pd=0 as=0 ps=0 w=508 l=56
X2556 NAND3_28/m1_n2243_n1314# NAND3_28/a_n593_982# GND GND nfet_03v3 ad=0 pd=0 as=0 ps=0 w=508 l=56
X2557 NAND3_28/m1_n3706_n1374# comp[33] NAND3_28/a_2506_982# GND nfet_03v3 ad=0 pd=0 as=0.10566u ps=2.448m w=508 l=56
X2558 NAND3_28/m1_n3706_n1374# comp[33] NAND3_28/a_2506_982# GND nfet_03v3 ad=0 pd=0 as=0 ps=0 w=508 l=56
X2559 NAND3_28/a_2506_982# comp[33] NAND3_28/m1_n3706_n1374# GND nfet_03v3 ad=0 pd=0 as=0 ps=0 w=508 l=56
X2560 NAND3_28/a_2506_982# comp[33] NAND3_28/m1_n3706_n1374# GND nfet_03v3 ad=0 pd=0 as=0 ps=0 w=508 l=56
X2561 GND NAND3_28/a_2506_982# wl[34] GND nfet_03v3 ad=0 pd=0 as=0.10566u ps=2.448m w=508 l=56
X2562 GND NAND3_28/a_2506_982# wl[34] GND nfet_03v3 ad=0 pd=0 as=0 ps=0 w=508 l=56
X2563 wl[34] NAND3_28/a_2506_982# GND GND nfet_03v3 ad=0 pd=0 as=0 ps=0 w=508 l=56
X2564 wl[34] NAND3_28/a_2506_982# GND GND nfet_03v3 ad=0 pd=0 as=0 ps=0 w=508 l=56
X2565 VDD comp[24] NAND3_39/a_n593_982# VDD pfet_03v3 ad=0 pd=0 as=0.22308u ps=4.636m w=660 l=56
X2566 NAND3_39/a_n593_982# comp[24] VDD VDD pfet_03v3 ad=0 pd=0 as=0 ps=0 w=660 l=56
X2567 NAND3_39/a_n593_982# comp[24] VDD VDD pfet_03v3 ad=0 pd=0 as=0 ps=0 w=660 l=56
X2568 VDD comp[24] NAND3_39/a_n593_982# VDD pfet_03v3 ad=0 pd=0 as=0 ps=0 w=660 l=56
X2569 VDD comp[24] NAND3_39/a_n593_982# VDD pfet_03v3 ad=0 pd=0 as=0 ps=0 w=660 l=56
X2570 VDD comp[23] NAND3_39/a_2506_982# VDD pfet_03v3 ad=0 pd=0 as=0.66924u ps=0.01391 w=660 l=56
X2571 NAND3_39/a_2506_982# comp[23] VDD VDD pfet_03v3 ad=0 pd=0 as=0 ps=0 w=660 l=56
X2572 NAND3_39/a_2506_982# comp[23] VDD VDD pfet_03v3 ad=0 pd=0 as=0 ps=0 w=660 l=56
X2573 VDD comp[23] NAND3_39/a_2506_982# VDD pfet_03v3 ad=0 pd=0 as=0 ps=0 w=660 l=56
X2574 VDD comp[23] NAND3_39/a_2506_982# VDD pfet_03v3 ad=0 pd=0 as=0 ps=0 w=660 l=56
X2575 VDD comp[22] NAND3_39/a_2506_982# VDD pfet_03v3 ad=0 pd=0 as=0 ps=0 w=660 l=56
X2576 NAND3_39/a_2506_982# comp[22] VDD VDD pfet_03v3 ad=0 pd=0 as=0 ps=0 w=660 l=56
X2577 NAND3_39/a_2506_982# comp[22] VDD VDD pfet_03v3 ad=0 pd=0 as=0 ps=0 w=660 l=56
X2578 VDD comp[22] NAND3_39/a_2506_982# VDD pfet_03v3 ad=0 pd=0 as=0 ps=0 w=660 l=56
X2579 VDD comp[22] NAND3_39/a_2506_982# VDD pfet_03v3 ad=0 pd=0 as=0 ps=0 w=660 l=56
X2580 VDD NAND3_39/a_2506_982# wl[23] VDD pfet_03v3 ad=0 pd=0 as=0.22308u ps=4.636m w=660 l=56
X2581 wl[23] NAND3_39/a_2506_982# VDD VDD pfet_03v3 ad=0 pd=0 as=0 ps=0 w=660 l=56
X2582 wl[23] NAND3_39/a_2506_982# VDD VDD pfet_03v3 ad=0 pd=0 as=0 ps=0 w=660 l=56
X2583 VDD NAND3_39/a_2506_982# wl[23] VDD pfet_03v3 ad=0 pd=0 as=0 ps=0 w=660 l=56
X2584 VDD NAND3_39/a_2506_982# wl[23] VDD pfet_03v3 ad=0 pd=0 as=0 ps=0 w=660 l=56
X2585 VDD NAND3_39/a_n593_982# NAND3_39/a_2506_982# VDD pfet_03v3 ad=0 pd=0 as=0 ps=0 w=660 l=56
X2586 NAND3_39/a_2506_982# NAND3_39/a_n593_982# VDD VDD pfet_03v3 ad=0 pd=0 as=0 ps=0 w=660 l=56
X2587 NAND3_39/a_2506_982# NAND3_39/a_n593_982# VDD VDD pfet_03v3 ad=0 pd=0 as=0 ps=0 w=660 l=56
X2588 VDD NAND3_39/a_n593_982# NAND3_39/a_2506_982# VDD pfet_03v3 ad=0 pd=0 as=0 ps=0 w=660 l=56
X2589 VDD NAND3_39/a_n593_982# NAND3_39/a_2506_982# VDD pfet_03v3 ad=0 pd=0 as=0 ps=0 w=660 l=56
X2590 NAND3_39/m1_n2243_n1314# comp[23] NAND3_39/m1_n3706_n1374# GND nfet_03v3 ad=0.28245u pd=6.192m as=0.28245u ps=6.192m w=508 l=56
X2591 NAND3_39/m1_n2243_n1314# comp[23] NAND3_39/m1_n3706_n1374# GND nfet_03v3 ad=0 pd=0 as=0 ps=0 w=508 l=56
X2592 NAND3_39/m1_n3706_n1374# comp[23] NAND3_39/m1_n2243_n1314# GND nfet_03v3 ad=0 pd=0 as=0 ps=0 w=508 l=56
X2593 NAND3_39/m1_n3706_n1374# comp[23] NAND3_39/m1_n2243_n1314# GND nfet_03v3 ad=0 pd=0 as=0 ps=0 w=508 l=56
X2594 GND comp[24] NAND3_39/a_n593_982# GND nfet_03v3 ad=0 pd=0 as=0.10566u ps=2.448m w=508 l=56
X2595 GND comp[24] NAND3_39/a_n593_982# GND nfet_03v3 ad=0 pd=0 as=0 ps=0 w=508 l=56
X2596 NAND3_39/a_n593_982# comp[24] GND GND nfet_03v3 ad=0 pd=0 as=0 ps=0 w=508 l=56
X2597 NAND3_39/a_n593_982# comp[24] GND GND nfet_03v3 ad=0 pd=0 as=0 ps=0 w=508 l=56
X2598 GND NAND3_39/a_n593_982# NAND3_39/m1_n2243_n1314# GND nfet_03v3 ad=0 pd=0 as=0 ps=0 w=508 l=56
X2599 GND NAND3_39/a_n593_982# NAND3_39/m1_n2243_n1314# GND nfet_03v3 ad=0 pd=0 as=0 ps=0 w=508 l=56
X2600 NAND3_39/m1_n2243_n1314# NAND3_39/a_n593_982# GND GND nfet_03v3 ad=0 pd=0 as=0 ps=0 w=508 l=56
X2601 NAND3_39/m1_n2243_n1314# NAND3_39/a_n593_982# GND GND nfet_03v3 ad=0 pd=0 as=0 ps=0 w=508 l=56
X2602 NAND3_39/m1_n3706_n1374# comp[22] NAND3_39/a_2506_982# GND nfet_03v3 ad=0 pd=0 as=0.10566u ps=2.448m w=508 l=56
X2603 NAND3_39/m1_n3706_n1374# comp[22] NAND3_39/a_2506_982# GND nfet_03v3 ad=0 pd=0 as=0 ps=0 w=508 l=56
X2604 NAND3_39/a_2506_982# comp[22] NAND3_39/m1_n3706_n1374# GND nfet_03v3 ad=0 pd=0 as=0 ps=0 w=508 l=56
X2605 NAND3_39/a_2506_982# comp[22] NAND3_39/m1_n3706_n1374# GND nfet_03v3 ad=0 pd=0 as=0 ps=0 w=508 l=56
X2606 GND NAND3_39/a_2506_982# wl[23] GND nfet_03v3 ad=0 pd=0 as=0.10566u ps=2.448m w=508 l=56
X2607 GND NAND3_39/a_2506_982# wl[23] GND nfet_03v3 ad=0 pd=0 as=0 ps=0 w=508 l=56
X2608 wl[23] NAND3_39/a_2506_982# GND GND nfet_03v3 ad=0 pd=0 as=0 ps=0 w=508 l=56
X2609 wl[23] NAND3_39/a_2506_982# GND GND nfet_03v3 ad=0 pd=0 as=0 ps=0 w=508 l=56
X2610 VDD comp[55] NAND3_8/a_n593_982# VDD pfet_03v3 ad=0 pd=0 as=0.22308u ps=4.636m w=660 l=56
X2611 NAND3_8/a_n593_982# comp[55] VDD VDD pfet_03v3 ad=0 pd=0 as=0 ps=0 w=660 l=56
X2612 NAND3_8/a_n593_982# comp[55] VDD VDD pfet_03v3 ad=0 pd=0 as=0 ps=0 w=660 l=56
X2613 VDD comp[55] NAND3_8/a_n593_982# VDD pfet_03v3 ad=0 pd=0 as=0 ps=0 w=660 l=56
X2614 VDD comp[55] NAND3_8/a_n593_982# VDD pfet_03v3 ad=0 pd=0 as=0 ps=0 w=660 l=56
X2615 VDD comp[54] NAND3_8/a_2506_982# VDD pfet_03v3 ad=0 pd=0 as=0.66924u ps=0.01391 w=660 l=56
X2616 NAND3_8/a_2506_982# comp[54] VDD VDD pfet_03v3 ad=0 pd=0 as=0 ps=0 w=660 l=56
X2617 NAND3_8/a_2506_982# comp[54] VDD VDD pfet_03v3 ad=0 pd=0 as=0 ps=0 w=660 l=56
X2618 VDD comp[54] NAND3_8/a_2506_982# VDD pfet_03v3 ad=0 pd=0 as=0 ps=0 w=660 l=56
X2619 VDD comp[54] NAND3_8/a_2506_982# VDD pfet_03v3 ad=0 pd=0 as=0 ps=0 w=660 l=56
X2620 VDD comp[53] NAND3_8/a_2506_982# VDD pfet_03v3 ad=0 pd=0 as=0 ps=0 w=660 l=56
X2621 NAND3_8/a_2506_982# comp[53] VDD VDD pfet_03v3 ad=0 pd=0 as=0 ps=0 w=660 l=56
X2622 NAND3_8/a_2506_982# comp[53] VDD VDD pfet_03v3 ad=0 pd=0 as=0 ps=0 w=660 l=56
X2623 VDD comp[53] NAND3_8/a_2506_982# VDD pfet_03v3 ad=0 pd=0 as=0 ps=0 w=660 l=56
X2624 VDD comp[53] NAND3_8/a_2506_982# VDD pfet_03v3 ad=0 pd=0 as=0 ps=0 w=660 l=56
X2625 VDD NAND3_8/a_2506_982# wl[54] VDD pfet_03v3 ad=0 pd=0 as=0.22308u ps=4.636m w=660 l=56
X2626 wl[54] NAND3_8/a_2506_982# VDD VDD pfet_03v3 ad=0 pd=0 as=0 ps=0 w=660 l=56
X2627 wl[54] NAND3_8/a_2506_982# VDD VDD pfet_03v3 ad=0 pd=0 as=0 ps=0 w=660 l=56
X2628 VDD NAND3_8/a_2506_982# wl[54] VDD pfet_03v3 ad=0 pd=0 as=0 ps=0 w=660 l=56
X2629 VDD NAND3_8/a_2506_982# wl[54] VDD pfet_03v3 ad=0 pd=0 as=0 ps=0 w=660 l=56
X2630 VDD NAND3_8/a_n593_982# NAND3_8/a_2506_982# VDD pfet_03v3 ad=0 pd=0 as=0 ps=0 w=660 l=56
X2631 NAND3_8/a_2506_982# NAND3_8/a_n593_982# VDD VDD pfet_03v3 ad=0 pd=0 as=0 ps=0 w=660 l=56
X2632 NAND3_8/a_2506_982# NAND3_8/a_n593_982# VDD VDD pfet_03v3 ad=0 pd=0 as=0 ps=0 w=660 l=56
X2633 VDD NAND3_8/a_n593_982# NAND3_8/a_2506_982# VDD pfet_03v3 ad=0 pd=0 as=0 ps=0 w=660 l=56
X2634 VDD NAND3_8/a_n593_982# NAND3_8/a_2506_982# VDD pfet_03v3 ad=0 pd=0 as=0 ps=0 w=660 l=56
X2635 NAND3_8/m1_n2243_n1314# comp[54] NAND3_8/m1_n3706_n1374# GND nfet_03v3 ad=0.28245u pd=6.192m as=0.28245u ps=6.192m w=508 l=56
X2636 NAND3_8/m1_n2243_n1314# comp[54] NAND3_8/m1_n3706_n1374# GND nfet_03v3 ad=0 pd=0 as=0 ps=0 w=508 l=56
X2637 NAND3_8/m1_n3706_n1374# comp[54] NAND3_8/m1_n2243_n1314# GND nfet_03v3 ad=0 pd=0 as=0 ps=0 w=508 l=56
X2638 NAND3_8/m1_n3706_n1374# comp[54] NAND3_8/m1_n2243_n1314# GND nfet_03v3 ad=0 pd=0 as=0 ps=0 w=508 l=56
X2639 GND comp[55] NAND3_8/a_n593_982# GND nfet_03v3 ad=0 pd=0 as=0.10566u ps=2.448m w=508 l=56
X2640 GND comp[55] NAND3_8/a_n593_982# GND nfet_03v3 ad=0 pd=0 as=0 ps=0 w=508 l=56
X2641 NAND3_8/a_n593_982# comp[55] GND GND nfet_03v3 ad=0 pd=0 as=0 ps=0 w=508 l=56
X2642 NAND3_8/a_n593_982# comp[55] GND GND nfet_03v3 ad=0 pd=0 as=0 ps=0 w=508 l=56
X2643 GND NAND3_8/a_n593_982# NAND3_8/m1_n2243_n1314# GND nfet_03v3 ad=0 pd=0 as=0 ps=0 w=508 l=56
X2644 GND NAND3_8/a_n593_982# NAND3_8/m1_n2243_n1314# GND nfet_03v3 ad=0 pd=0 as=0 ps=0 w=508 l=56
X2645 NAND3_8/m1_n2243_n1314# NAND3_8/a_n593_982# GND GND nfet_03v3 ad=0 pd=0 as=0 ps=0 w=508 l=56
X2646 NAND3_8/m1_n2243_n1314# NAND3_8/a_n593_982# GND GND nfet_03v3 ad=0 pd=0 as=0 ps=0 w=508 l=56
X2647 NAND3_8/m1_n3706_n1374# comp[53] NAND3_8/a_2506_982# GND nfet_03v3 ad=0 pd=0 as=0.10566u ps=2.448m w=508 l=56
X2648 NAND3_8/m1_n3706_n1374# comp[53] NAND3_8/a_2506_982# GND nfet_03v3 ad=0 pd=0 as=0 ps=0 w=508 l=56
X2649 NAND3_8/a_2506_982# comp[53] NAND3_8/m1_n3706_n1374# GND nfet_03v3 ad=0 pd=0 as=0 ps=0 w=508 l=56
X2650 NAND3_8/a_2506_982# comp[53] NAND3_8/m1_n3706_n1374# GND nfet_03v3 ad=0 pd=0 as=0 ps=0 w=508 l=56
X2651 GND NAND3_8/a_2506_982# wl[54] GND nfet_03v3 ad=0 pd=0 as=0.10566u ps=2.448m w=508 l=56
X2652 GND NAND3_8/a_2506_982# wl[54] GND nfet_03v3 ad=0 pd=0 as=0 ps=0 w=508 l=56
X2653 wl[54] NAND3_8/a_2506_982# GND GND nfet_03v3 ad=0 pd=0 as=0 ps=0 w=508 l=56
X2654 wl[54] NAND3_8/a_2506_982# GND GND nfet_03v3 ad=0 pd=0 as=0 ps=0 w=508 l=56
X2655 VDD comp[45] NAND3_18/a_n593_982# VDD pfet_03v3 ad=0 pd=0 as=0.22308u ps=4.636m w=660 l=56
X2656 NAND3_18/a_n593_982# comp[45] VDD VDD pfet_03v3 ad=0 pd=0 as=0 ps=0 w=660 l=56
X2657 NAND3_18/a_n593_982# comp[45] VDD VDD pfet_03v3 ad=0 pd=0 as=0 ps=0 w=660 l=56
X2658 VDD comp[45] NAND3_18/a_n593_982# VDD pfet_03v3 ad=0 pd=0 as=0 ps=0 w=660 l=56
X2659 VDD comp[45] NAND3_18/a_n593_982# VDD pfet_03v3 ad=0 pd=0 as=0 ps=0 w=660 l=56
X2660 VDD comp[44] NAND3_18/a_2506_982# VDD pfet_03v3 ad=0 pd=0 as=0.66924u ps=0.01391 w=660 l=56
X2661 NAND3_18/a_2506_982# comp[44] VDD VDD pfet_03v3 ad=0 pd=0 as=0 ps=0 w=660 l=56
X2662 NAND3_18/a_2506_982# comp[44] VDD VDD pfet_03v3 ad=0 pd=0 as=0 ps=0 w=660 l=56
X2663 VDD comp[44] NAND3_18/a_2506_982# VDD pfet_03v3 ad=0 pd=0 as=0 ps=0 w=660 l=56
X2664 VDD comp[44] NAND3_18/a_2506_982# VDD pfet_03v3 ad=0 pd=0 as=0 ps=0 w=660 l=56
X2665 VDD comp[43] NAND3_18/a_2506_982# VDD pfet_03v3 ad=0 pd=0 as=0 ps=0 w=660 l=56
X2666 NAND3_18/a_2506_982# comp[43] VDD VDD pfet_03v3 ad=0 pd=0 as=0 ps=0 w=660 l=56
X2667 NAND3_18/a_2506_982# comp[43] VDD VDD pfet_03v3 ad=0 pd=0 as=0 ps=0 w=660 l=56
X2668 VDD comp[43] NAND3_18/a_2506_982# VDD pfet_03v3 ad=0 pd=0 as=0 ps=0 w=660 l=56
X2669 VDD comp[43] NAND3_18/a_2506_982# VDD pfet_03v3 ad=0 pd=0 as=0 ps=0 w=660 l=56
X2670 VDD NAND3_18/a_2506_982# wl[44] VDD pfet_03v3 ad=0 pd=0 as=0.22308u ps=4.636m w=660 l=56
X2671 wl[44] NAND3_18/a_2506_982# VDD VDD pfet_03v3 ad=0 pd=0 as=0 ps=0 w=660 l=56
X2672 wl[44] NAND3_18/a_2506_982# VDD VDD pfet_03v3 ad=0 pd=0 as=0 ps=0 w=660 l=56
X2673 VDD NAND3_18/a_2506_982# wl[44] VDD pfet_03v3 ad=0 pd=0 as=0 ps=0 w=660 l=56
X2674 VDD NAND3_18/a_2506_982# wl[44] VDD pfet_03v3 ad=0 pd=0 as=0 ps=0 w=660 l=56
X2675 VDD NAND3_18/a_n593_982# NAND3_18/a_2506_982# VDD pfet_03v3 ad=0 pd=0 as=0 ps=0 w=660 l=56
X2676 NAND3_18/a_2506_982# NAND3_18/a_n593_982# VDD VDD pfet_03v3 ad=0 pd=0 as=0 ps=0 w=660 l=56
X2677 NAND3_18/a_2506_982# NAND3_18/a_n593_982# VDD VDD pfet_03v3 ad=0 pd=0 as=0 ps=0 w=660 l=56
X2678 VDD NAND3_18/a_n593_982# NAND3_18/a_2506_982# VDD pfet_03v3 ad=0 pd=0 as=0 ps=0 w=660 l=56
X2679 VDD NAND3_18/a_n593_982# NAND3_18/a_2506_982# VDD pfet_03v3 ad=0 pd=0 as=0 ps=0 w=660 l=56
X2680 NAND3_18/m1_n2243_n1314# comp[44] NAND3_18/m1_n3706_n1374# GND nfet_03v3 ad=0.28245u pd=6.192m as=0.28245u ps=6.192m w=508 l=56
X2681 NAND3_18/m1_n2243_n1314# comp[44] NAND3_18/m1_n3706_n1374# GND nfet_03v3 ad=0 pd=0 as=0 ps=0 w=508 l=56
X2682 NAND3_18/m1_n3706_n1374# comp[44] NAND3_18/m1_n2243_n1314# GND nfet_03v3 ad=0 pd=0 as=0 ps=0 w=508 l=56
X2683 NAND3_18/m1_n3706_n1374# comp[44] NAND3_18/m1_n2243_n1314# GND nfet_03v3 ad=0 pd=0 as=0 ps=0 w=508 l=56
X2684 GND comp[45] NAND3_18/a_n593_982# GND nfet_03v3 ad=0 pd=0 as=0.10566u ps=2.448m w=508 l=56
X2685 GND comp[45] NAND3_18/a_n593_982# GND nfet_03v3 ad=0 pd=0 as=0 ps=0 w=508 l=56
X2686 NAND3_18/a_n593_982# comp[45] GND GND nfet_03v3 ad=0 pd=0 as=0 ps=0 w=508 l=56
X2687 NAND3_18/a_n593_982# comp[45] GND GND nfet_03v3 ad=0 pd=0 as=0 ps=0 w=508 l=56
X2688 GND NAND3_18/a_n593_982# NAND3_18/m1_n2243_n1314# GND nfet_03v3 ad=0 pd=0 as=0 ps=0 w=508 l=56
X2689 GND NAND3_18/a_n593_982# NAND3_18/m1_n2243_n1314# GND nfet_03v3 ad=0 pd=0 as=0 ps=0 w=508 l=56
X2690 NAND3_18/m1_n2243_n1314# NAND3_18/a_n593_982# GND GND nfet_03v3 ad=0 pd=0 as=0 ps=0 w=508 l=56
X2691 NAND3_18/m1_n2243_n1314# NAND3_18/a_n593_982# GND GND nfet_03v3 ad=0 pd=0 as=0 ps=0 w=508 l=56
X2692 NAND3_18/m1_n3706_n1374# comp[43] NAND3_18/a_2506_982# GND nfet_03v3 ad=0 pd=0 as=0.10566u ps=2.448m w=508 l=56
X2693 NAND3_18/m1_n3706_n1374# comp[43] NAND3_18/a_2506_982# GND nfet_03v3 ad=0 pd=0 as=0 ps=0 w=508 l=56
X2694 NAND3_18/a_2506_982# comp[43] NAND3_18/m1_n3706_n1374# GND nfet_03v3 ad=0 pd=0 as=0 ps=0 w=508 l=56
X2695 NAND3_18/a_2506_982# comp[43] NAND3_18/m1_n3706_n1374# GND nfet_03v3 ad=0 pd=0 as=0 ps=0 w=508 l=56
X2696 GND NAND3_18/a_2506_982# wl[44] GND nfet_03v3 ad=0 pd=0 as=0.10566u ps=2.448m w=508 l=56
X2697 GND NAND3_18/a_2506_982# wl[44] GND nfet_03v3 ad=0 pd=0 as=0 ps=0 w=508 l=56
X2698 wl[44] NAND3_18/a_2506_982# GND GND nfet_03v3 ad=0 pd=0 as=0 ps=0 w=508 l=56
X2699 wl[44] NAND3_18/a_2506_982# GND GND nfet_03v3 ad=0 pd=0 as=0 ps=0 w=508 l=56
X2700 VDD comp[34] NAND3_29/a_n593_982# VDD pfet_03v3 ad=0 pd=0 as=0.22308u ps=4.636m w=660 l=56
X2701 NAND3_29/a_n593_982# comp[34] VDD VDD pfet_03v3 ad=0 pd=0 as=0 ps=0 w=660 l=56
X2702 NAND3_29/a_n593_982# comp[34] VDD VDD pfet_03v3 ad=0 pd=0 as=0 ps=0 w=660 l=56
X2703 VDD comp[34] NAND3_29/a_n593_982# VDD pfet_03v3 ad=0 pd=0 as=0 ps=0 w=660 l=56
X2704 VDD comp[34] NAND3_29/a_n593_982# VDD pfet_03v3 ad=0 pd=0 as=0 ps=0 w=660 l=56
X2705 VDD comp[33] NAND3_29/a_2506_982# VDD pfet_03v3 ad=0 pd=0 as=0.66924u ps=0.01391 w=660 l=56
X2706 NAND3_29/a_2506_982# comp[33] VDD VDD pfet_03v3 ad=0 pd=0 as=0 ps=0 w=660 l=56
X2707 NAND3_29/a_2506_982# comp[33] VDD VDD pfet_03v3 ad=0 pd=0 as=0 ps=0 w=660 l=56
X2708 VDD comp[33] NAND3_29/a_2506_982# VDD pfet_03v3 ad=0 pd=0 as=0 ps=0 w=660 l=56
X2709 VDD comp[33] NAND3_29/a_2506_982# VDD pfet_03v3 ad=0 pd=0 as=0 ps=0 w=660 l=56
X2710 VDD comp[32] NAND3_29/a_2506_982# VDD pfet_03v3 ad=0 pd=0 as=0 ps=0 w=660 l=56
X2711 NAND3_29/a_2506_982# comp[32] VDD VDD pfet_03v3 ad=0 pd=0 as=0 ps=0 w=660 l=56
X2712 NAND3_29/a_2506_982# comp[32] VDD VDD pfet_03v3 ad=0 pd=0 as=0 ps=0 w=660 l=56
X2713 VDD comp[32] NAND3_29/a_2506_982# VDD pfet_03v3 ad=0 pd=0 as=0 ps=0 w=660 l=56
X2714 VDD comp[32] NAND3_29/a_2506_982# VDD pfet_03v3 ad=0 pd=0 as=0 ps=0 w=660 l=56
X2715 VDD NAND3_29/a_2506_982# wl[33] VDD pfet_03v3 ad=0 pd=0 as=0.22308u ps=4.636m w=660 l=56
X2716 wl[33] NAND3_29/a_2506_982# VDD VDD pfet_03v3 ad=0 pd=0 as=0 ps=0 w=660 l=56
X2717 wl[33] NAND3_29/a_2506_982# VDD VDD pfet_03v3 ad=0 pd=0 as=0 ps=0 w=660 l=56
X2718 VDD NAND3_29/a_2506_982# wl[33] VDD pfet_03v3 ad=0 pd=0 as=0 ps=0 w=660 l=56
X2719 VDD NAND3_29/a_2506_982# wl[33] VDD pfet_03v3 ad=0 pd=0 as=0 ps=0 w=660 l=56
X2720 VDD NAND3_29/a_n593_982# NAND3_29/a_2506_982# VDD pfet_03v3 ad=0 pd=0 as=0 ps=0 w=660 l=56
X2721 NAND3_29/a_2506_982# NAND3_29/a_n593_982# VDD VDD pfet_03v3 ad=0 pd=0 as=0 ps=0 w=660 l=56
X2722 NAND3_29/a_2506_982# NAND3_29/a_n593_982# VDD VDD pfet_03v3 ad=0 pd=0 as=0 ps=0 w=660 l=56
X2723 VDD NAND3_29/a_n593_982# NAND3_29/a_2506_982# VDD pfet_03v3 ad=0 pd=0 as=0 ps=0 w=660 l=56
X2724 VDD NAND3_29/a_n593_982# NAND3_29/a_2506_982# VDD pfet_03v3 ad=0 pd=0 as=0 ps=0 w=660 l=56
X2725 NAND3_29/m1_n2243_n1314# comp[33] NAND3_29/m1_n3706_n1374# GND nfet_03v3 ad=0.28245u pd=6.192m as=0.28245u ps=6.192m w=508 l=56
X2726 NAND3_29/m1_n2243_n1314# comp[33] NAND3_29/m1_n3706_n1374# GND nfet_03v3 ad=0 pd=0 as=0 ps=0 w=508 l=56
X2727 NAND3_29/m1_n3706_n1374# comp[33] NAND3_29/m1_n2243_n1314# GND nfet_03v3 ad=0 pd=0 as=0 ps=0 w=508 l=56
X2728 NAND3_29/m1_n3706_n1374# comp[33] NAND3_29/m1_n2243_n1314# GND nfet_03v3 ad=0 pd=0 as=0 ps=0 w=508 l=56
X2729 GND comp[34] NAND3_29/a_n593_982# GND nfet_03v3 ad=0 pd=0 as=0.10566u ps=2.448m w=508 l=56
X2730 GND comp[34] NAND3_29/a_n593_982# GND nfet_03v3 ad=0 pd=0 as=0 ps=0 w=508 l=56
X2731 NAND3_29/a_n593_982# comp[34] GND GND nfet_03v3 ad=0 pd=0 as=0 ps=0 w=508 l=56
X2732 NAND3_29/a_n593_982# comp[34] GND GND nfet_03v3 ad=0 pd=0 as=0 ps=0 w=508 l=56
X2733 GND NAND3_29/a_n593_982# NAND3_29/m1_n2243_n1314# GND nfet_03v3 ad=0 pd=0 as=0 ps=0 w=508 l=56
X2734 GND NAND3_29/a_n593_982# NAND3_29/m1_n2243_n1314# GND nfet_03v3 ad=0 pd=0 as=0 ps=0 w=508 l=56
X2735 NAND3_29/m1_n2243_n1314# NAND3_29/a_n593_982# GND GND nfet_03v3 ad=0 pd=0 as=0 ps=0 w=508 l=56
X2736 NAND3_29/m1_n2243_n1314# NAND3_29/a_n593_982# GND GND nfet_03v3 ad=0 pd=0 as=0 ps=0 w=508 l=56
X2737 NAND3_29/m1_n3706_n1374# comp[32] NAND3_29/a_2506_982# GND nfet_03v3 ad=0 pd=0 as=0.10566u ps=2.448m w=508 l=56
X2738 NAND3_29/m1_n3706_n1374# comp[32] NAND3_29/a_2506_982# GND nfet_03v3 ad=0 pd=0 as=0 ps=0 w=508 l=56
X2739 NAND3_29/a_2506_982# comp[32] NAND3_29/m1_n3706_n1374# GND nfet_03v3 ad=0 pd=0 as=0 ps=0 w=508 l=56
X2740 NAND3_29/a_2506_982# comp[32] NAND3_29/m1_n3706_n1374# GND nfet_03v3 ad=0 pd=0 as=0 ps=0 w=508 l=56
X2741 GND NAND3_29/a_2506_982# wl[33] GND nfet_03v3 ad=0 pd=0 as=0.10566u ps=2.448m w=508 l=56
X2742 GND NAND3_29/a_2506_982# wl[33] GND nfet_03v3 ad=0 pd=0 as=0 ps=0 w=508 l=56
X2743 wl[33] NAND3_29/a_2506_982# GND GND nfet_03v3 ad=0 pd=0 as=0 ps=0 w=508 l=56
X2744 wl[33] NAND3_29/a_2506_982# GND GND nfet_03v3 ad=0 pd=0 as=0 ps=0 w=508 l=56
X2745 VDD comp[54] NAND3_9/a_n593_982# VDD pfet_03v3 ad=0 pd=0 as=0.22308u ps=4.636m w=660 l=56
X2746 NAND3_9/a_n593_982# comp[54] VDD VDD pfet_03v3 ad=0 pd=0 as=0 ps=0 w=660 l=56
X2747 NAND3_9/a_n593_982# comp[54] VDD VDD pfet_03v3 ad=0 pd=0 as=0 ps=0 w=660 l=56
X2748 VDD comp[54] NAND3_9/a_n593_982# VDD pfet_03v3 ad=0 pd=0 as=0 ps=0 w=660 l=56
X2749 VDD comp[54] NAND3_9/a_n593_982# VDD pfet_03v3 ad=0 pd=0 as=0 ps=0 w=660 l=56
X2750 VDD comp[53] NAND3_9/a_2506_982# VDD pfet_03v3 ad=0 pd=0 as=0.66924u ps=0.01391 w=660 l=56
X2751 NAND3_9/a_2506_982# comp[53] VDD VDD pfet_03v3 ad=0 pd=0 as=0 ps=0 w=660 l=56
X2752 NAND3_9/a_2506_982# comp[53] VDD VDD pfet_03v3 ad=0 pd=0 as=0 ps=0 w=660 l=56
X2753 VDD comp[53] NAND3_9/a_2506_982# VDD pfet_03v3 ad=0 pd=0 as=0 ps=0 w=660 l=56
X2754 VDD comp[53] NAND3_9/a_2506_982# VDD pfet_03v3 ad=0 pd=0 as=0 ps=0 w=660 l=56
X2755 VDD comp[52] NAND3_9/a_2506_982# VDD pfet_03v3 ad=0 pd=0 as=0 ps=0 w=660 l=56
X2756 NAND3_9/a_2506_982# comp[52] VDD VDD pfet_03v3 ad=0 pd=0 as=0 ps=0 w=660 l=56
X2757 NAND3_9/a_2506_982# comp[52] VDD VDD pfet_03v3 ad=0 pd=0 as=0 ps=0 w=660 l=56
X2758 VDD comp[52] NAND3_9/a_2506_982# VDD pfet_03v3 ad=0 pd=0 as=0 ps=0 w=660 l=56
X2759 VDD comp[52] NAND3_9/a_2506_982# VDD pfet_03v3 ad=0 pd=0 as=0 ps=0 w=660 l=56
X2760 VDD NAND3_9/a_2506_982# wl[53] VDD pfet_03v3 ad=0 pd=0 as=0.22308u ps=4.636m w=660 l=56
X2761 wl[53] NAND3_9/a_2506_982# VDD VDD pfet_03v3 ad=0 pd=0 as=0 ps=0 w=660 l=56
X2762 wl[53] NAND3_9/a_2506_982# VDD VDD pfet_03v3 ad=0 pd=0 as=0 ps=0 w=660 l=56
X2763 VDD NAND3_9/a_2506_982# wl[53] VDD pfet_03v3 ad=0 pd=0 as=0 ps=0 w=660 l=56
X2764 VDD NAND3_9/a_2506_982# wl[53] VDD pfet_03v3 ad=0 pd=0 as=0 ps=0 w=660 l=56
X2765 VDD NAND3_9/a_n593_982# NAND3_9/a_2506_982# VDD pfet_03v3 ad=0 pd=0 as=0 ps=0 w=660 l=56
X2766 NAND3_9/a_2506_982# NAND3_9/a_n593_982# VDD VDD pfet_03v3 ad=0 pd=0 as=0 ps=0 w=660 l=56
X2767 NAND3_9/a_2506_982# NAND3_9/a_n593_982# VDD VDD pfet_03v3 ad=0 pd=0 as=0 ps=0 w=660 l=56
X2768 VDD NAND3_9/a_n593_982# NAND3_9/a_2506_982# VDD pfet_03v3 ad=0 pd=0 as=0 ps=0 w=660 l=56
X2769 VDD NAND3_9/a_n593_982# NAND3_9/a_2506_982# VDD pfet_03v3 ad=0 pd=0 as=0 ps=0 w=660 l=56
X2770 NAND3_9/m1_n2243_n1314# comp[53] NAND3_9/m1_n3706_n1374# GND nfet_03v3 ad=0.28245u pd=6.192m as=0.28245u ps=6.192m w=508 l=56
X2771 NAND3_9/m1_n2243_n1314# comp[53] NAND3_9/m1_n3706_n1374# GND nfet_03v3 ad=0 pd=0 as=0 ps=0 w=508 l=56
X2772 NAND3_9/m1_n3706_n1374# comp[53] NAND3_9/m1_n2243_n1314# GND nfet_03v3 ad=0 pd=0 as=0 ps=0 w=508 l=56
X2773 NAND3_9/m1_n3706_n1374# comp[53] NAND3_9/m1_n2243_n1314# GND nfet_03v3 ad=0 pd=0 as=0 ps=0 w=508 l=56
X2774 GND comp[54] NAND3_9/a_n593_982# GND nfet_03v3 ad=0 pd=0 as=0.10566u ps=2.448m w=508 l=56
X2775 GND comp[54] NAND3_9/a_n593_982# GND nfet_03v3 ad=0 pd=0 as=0 ps=0 w=508 l=56
X2776 NAND3_9/a_n593_982# comp[54] GND GND nfet_03v3 ad=0 pd=0 as=0 ps=0 w=508 l=56
X2777 NAND3_9/a_n593_982# comp[54] GND GND nfet_03v3 ad=0 pd=0 as=0 ps=0 w=508 l=56
X2778 GND NAND3_9/a_n593_982# NAND3_9/m1_n2243_n1314# GND nfet_03v3 ad=0 pd=0 as=0 ps=0 w=508 l=56
X2779 GND NAND3_9/a_n593_982# NAND3_9/m1_n2243_n1314# GND nfet_03v3 ad=0 pd=0 as=0 ps=0 w=508 l=56
X2780 NAND3_9/m1_n2243_n1314# NAND3_9/a_n593_982# GND GND nfet_03v3 ad=0 pd=0 as=0 ps=0 w=508 l=56
X2781 NAND3_9/m1_n2243_n1314# NAND3_9/a_n593_982# GND GND nfet_03v3 ad=0 pd=0 as=0 ps=0 w=508 l=56
X2782 NAND3_9/m1_n3706_n1374# comp[52] NAND3_9/a_2506_982# GND nfet_03v3 ad=0 pd=0 as=0.10566u ps=2.448m w=508 l=56
X2783 NAND3_9/m1_n3706_n1374# comp[52] NAND3_9/a_2506_982# GND nfet_03v3 ad=0 pd=0 as=0 ps=0 w=508 l=56
X2784 NAND3_9/a_2506_982# comp[52] NAND3_9/m1_n3706_n1374# GND nfet_03v3 ad=0 pd=0 as=0 ps=0 w=508 l=56
X2785 NAND3_9/a_2506_982# comp[52] NAND3_9/m1_n3706_n1374# GND nfet_03v3 ad=0 pd=0 as=0 ps=0 w=508 l=56
X2786 GND NAND3_9/a_2506_982# wl[53] GND nfet_03v3 ad=0 pd=0 as=0.10566u ps=2.448m w=508 l=56
X2787 GND NAND3_9/a_2506_982# wl[53] GND nfet_03v3 ad=0 pd=0 as=0 ps=0 w=508 l=56
X2788 wl[53] NAND3_9/a_2506_982# GND GND nfet_03v3 ad=0 pd=0 as=0 ps=0 w=508 l=56
X2789 wl[53] NAND3_9/a_2506_982# GND GND nfet_03v3 ad=0 pd=0 as=0 ps=0 w=508 l=56
X2790 VDD comp[44] NAND3_19/a_n593_982# VDD pfet_03v3 ad=0 pd=0 as=0.22308u ps=4.636m w=660 l=56
X2791 NAND3_19/a_n593_982# comp[44] VDD VDD pfet_03v3 ad=0 pd=0 as=0 ps=0 w=660 l=56
X2792 NAND3_19/a_n593_982# comp[44] VDD VDD pfet_03v3 ad=0 pd=0 as=0 ps=0 w=660 l=56
X2793 VDD comp[44] NAND3_19/a_n593_982# VDD pfet_03v3 ad=0 pd=0 as=0 ps=0 w=660 l=56
X2794 VDD comp[44] NAND3_19/a_n593_982# VDD pfet_03v3 ad=0 pd=0 as=0 ps=0 w=660 l=56
X2795 VDD comp[43] NAND3_19/a_2506_982# VDD pfet_03v3 ad=0 pd=0 as=0.66924u ps=0.01391 w=660 l=56
X2796 NAND3_19/a_2506_982# comp[43] VDD VDD pfet_03v3 ad=0 pd=0 as=0 ps=0 w=660 l=56
X2797 NAND3_19/a_2506_982# comp[43] VDD VDD pfet_03v3 ad=0 pd=0 as=0 ps=0 w=660 l=56
X2798 VDD comp[43] NAND3_19/a_2506_982# VDD pfet_03v3 ad=0 pd=0 as=0 ps=0 w=660 l=56
X2799 VDD comp[43] NAND3_19/a_2506_982# VDD pfet_03v3 ad=0 pd=0 as=0 ps=0 w=660 l=56
X2800 VDD comp[42] NAND3_19/a_2506_982# VDD pfet_03v3 ad=0 pd=0 as=0 ps=0 w=660 l=56
X2801 NAND3_19/a_2506_982# comp[42] VDD VDD pfet_03v3 ad=0 pd=0 as=0 ps=0 w=660 l=56
X2802 NAND3_19/a_2506_982# comp[42] VDD VDD pfet_03v3 ad=0 pd=0 as=0 ps=0 w=660 l=56
X2803 VDD comp[42] NAND3_19/a_2506_982# VDD pfet_03v3 ad=0 pd=0 as=0 ps=0 w=660 l=56
X2804 VDD comp[42] NAND3_19/a_2506_982# VDD pfet_03v3 ad=0 pd=0 as=0 ps=0 w=660 l=56
X2805 VDD NAND3_19/a_2506_982# wl[43] VDD pfet_03v3 ad=0 pd=0 as=0.22308u ps=4.636m w=660 l=56
X2806 wl[43] NAND3_19/a_2506_982# VDD VDD pfet_03v3 ad=0 pd=0 as=0 ps=0 w=660 l=56
X2807 wl[43] NAND3_19/a_2506_982# VDD VDD pfet_03v3 ad=0 pd=0 as=0 ps=0 w=660 l=56
X2808 VDD NAND3_19/a_2506_982# wl[43] VDD pfet_03v3 ad=0 pd=0 as=0 ps=0 w=660 l=56
X2809 VDD NAND3_19/a_2506_982# wl[43] VDD pfet_03v3 ad=0 pd=0 as=0 ps=0 w=660 l=56
X2810 VDD NAND3_19/a_n593_982# NAND3_19/a_2506_982# VDD pfet_03v3 ad=0 pd=0 as=0 ps=0 w=660 l=56
X2811 NAND3_19/a_2506_982# NAND3_19/a_n593_982# VDD VDD pfet_03v3 ad=0 pd=0 as=0 ps=0 w=660 l=56
X2812 NAND3_19/a_2506_982# NAND3_19/a_n593_982# VDD VDD pfet_03v3 ad=0 pd=0 as=0 ps=0 w=660 l=56
X2813 VDD NAND3_19/a_n593_982# NAND3_19/a_2506_982# VDD pfet_03v3 ad=0 pd=0 as=0 ps=0 w=660 l=56
X2814 VDD NAND3_19/a_n593_982# NAND3_19/a_2506_982# VDD pfet_03v3 ad=0 pd=0 as=0 ps=0 w=660 l=56
X2815 NAND3_19/m1_n2243_n1314# comp[43] NAND3_19/m1_n3706_n1374# GND nfet_03v3 ad=0.28245u pd=6.192m as=0.28245u ps=6.192m w=508 l=56
X2816 NAND3_19/m1_n2243_n1314# comp[43] NAND3_19/m1_n3706_n1374# GND nfet_03v3 ad=0 pd=0 as=0 ps=0 w=508 l=56
X2817 NAND3_19/m1_n3706_n1374# comp[43] NAND3_19/m1_n2243_n1314# GND nfet_03v3 ad=0 pd=0 as=0 ps=0 w=508 l=56
X2818 NAND3_19/m1_n3706_n1374# comp[43] NAND3_19/m1_n2243_n1314# GND nfet_03v3 ad=0 pd=0 as=0 ps=0 w=508 l=56
X2819 GND comp[44] NAND3_19/a_n593_982# GND nfet_03v3 ad=0 pd=0 as=0.10566u ps=2.448m w=508 l=56
X2820 GND comp[44] NAND3_19/a_n593_982# GND nfet_03v3 ad=0 pd=0 as=0 ps=0 w=508 l=56
X2821 NAND3_19/a_n593_982# comp[44] GND GND nfet_03v3 ad=0 pd=0 as=0 ps=0 w=508 l=56
X2822 NAND3_19/a_n593_982# comp[44] GND GND nfet_03v3 ad=0 pd=0 as=0 ps=0 w=508 l=56
X2823 GND NAND3_19/a_n593_982# NAND3_19/m1_n2243_n1314# GND nfet_03v3 ad=0 pd=0 as=0 ps=0 w=508 l=56
X2824 GND NAND3_19/a_n593_982# NAND3_19/m1_n2243_n1314# GND nfet_03v3 ad=0 pd=0 as=0 ps=0 w=508 l=56
X2825 NAND3_19/m1_n2243_n1314# NAND3_19/a_n593_982# GND GND nfet_03v3 ad=0 pd=0 as=0 ps=0 w=508 l=56
X2826 NAND3_19/m1_n2243_n1314# NAND3_19/a_n593_982# GND GND nfet_03v3 ad=0 pd=0 as=0 ps=0 w=508 l=56
X2827 NAND3_19/m1_n3706_n1374# comp[42] NAND3_19/a_2506_982# GND nfet_03v3 ad=0 pd=0 as=0.10566u ps=2.448m w=508 l=56
X2828 NAND3_19/m1_n3706_n1374# comp[42] NAND3_19/a_2506_982# GND nfet_03v3 ad=0 pd=0 as=0 ps=0 w=508 l=56
X2829 NAND3_19/a_2506_982# comp[42] NAND3_19/m1_n3706_n1374# GND nfet_03v3 ad=0 pd=0 as=0 ps=0 w=508 l=56
X2830 NAND3_19/a_2506_982# comp[42] NAND3_19/m1_n3706_n1374# GND nfet_03v3 ad=0 pd=0 as=0 ps=0 w=508 l=56
X2831 GND NAND3_19/a_2506_982# wl[43] GND nfet_03v3 ad=0 pd=0 as=0.10566u ps=2.448m w=508 l=56
X2832 GND NAND3_19/a_2506_982# wl[43] GND nfet_03v3 ad=0 pd=0 as=0 ps=0 w=508 l=56
X2833 wl[43] NAND3_19/a_2506_982# GND GND nfet_03v3 ad=0 pd=0 as=0 ps=0 w=508 l=56
X2834 wl[43] NAND3_19/a_2506_982# GND GND nfet_03v3 ad=0 pd=0 as=0 ps=0 w=508 l=56
C0 NAND3_3/m1_n3706_n1374# comp[59] 0.32609f
C1 comp[11] comp[12] 1.35332f
C2 NAND3_61/m1_n3706_n1374# comp[1] 0.34993f
C3 NAND3_45/a_2506_982# comp[17] 0.80459f
C4 NAND3_45/a_2506_982# NAND3_45/m1_n3706_n1374# 0.86518f
C5 comp[42] NAND3_20/a_2506_982# 0.9579f
C6 NAND3_18/a_n593_982# comp[44] 0.05055f
C7 comp[25] NAND3_37/m1_n2243_n1314# 0.16299f
C8 NAND3_38/a_n593_982# wl[24] 0.05101f
C9 NAND3_15/m1_n2243_n1314# comp[48] 0.20948f
C10 comp[21] NAND3_41/a_n593_982# 0.05055f
C11 wl[32] VDD 2.04641f
C12 NAND3_27/m1_n2243_n1314# NAND3_26/m1_n2243_n1314# 0.05788f
C13 comp[55] NAND3_7/m1_n3706_n1374# 0.34993f
C14 NAND3_14/m1_n2243_n1314# comp[48] 0.16299f
C15 comp[50] NAND3_13/a_2506_982# 0.30956f
C16 comp[19] NAND3_42/m1_n3706_n1374# 0.19865f
C17 m1_n4168_2156# comp[1] 2.2872f
C18 NAND3_36/m1_n3706_n1374# NAND3_37/m1_n3706_n1374# 0.05965f
C19 NAND3_31/m1_n2243_n1314# NAND3_30/m1_n2243_n1314# 0.05788f
C20 NAND3_9/a_2506_982# VDD 6.45473f
C21 comp[24] NAND3_38/a_n593_982# 0.05055f
C22 NAND3_42/m1_n2243_n1314# NAND3_42/m1_n3706_n1374# 0.9315f
C23 NAND3_28/a_n593_982# wl[34] 0.05101f
C24 comp[58] NAND3_4/a_2506_982# 0.87927f
C25 wl[54] NAND3_8/a_n593_982# 0.05101f
C26 comp[39] NAND3_23/a_n593_982# 0.05055f
C27 comp[40] VDD 3.0571f
C28 NAND3_7/a_n593_982# wl[55] 0.05101f
C29 comp[15] NAND3_46/a_2506_982# 0.99962f
C30 comp[58] comp[57] 2.58001f
C31 comp[30] NAND3_33/a_2506_982# 0.34787f
C32 NAND3_47/a_n593_982# comp[15] 0.05055f
C33 NAND3_41/m1_n2243_n1314# NAND3_40/m1_n2243_n1314# 0.05788f
C34 NAND3_47/a_2506_982# comp[14] 0.96225f
C35 comp[22] NAND3_41/a_n593_982# 1.40214f
C36 comp[14] NAND3_49/a_2506_982# 0.30956f
C37 NAND3_47/m1_n3706_n1374# comp[16] 0.2157f
C38 NAND3_24/a_n593_982# NAND3_24/a_2506_982# 1.12155f
C39 NAND3_59/m1_n2243_n1314# NAND3_59/a_n593_982# 0.33989f
C40 NAND3_61/m1_n3706_n1374# m1_n4168_2156# 0.17282f
C41 wl[53] VDD 2.04642f
C42 NAND3_58/a_2506_982# NAND3_58/m1_n3706_n1374# 0.86518f
C43 NAND3_36/a_2506_982# comp[26] 0.80389f
C44 NAND3_34/m1_n2243_n1314# comp[28] 0.16299f
C45 comp[54] NAND3_8/m1_n3706_n1374# 0.37506f
C46 NAND3_11/a_2506_982# NAND3_11/m1_n3706_n1374# 0.86518f
C47 comp[14] VDD 2.90414f
C48 NAND3_20/a_2506_982# NAND3_20/m1_n3706_n1374# 0.86518f
C49 comp[10] comp[12] 0.1031f
C50 wl[23] VDD 2.04642f
C51 comp[31] NAND3_32/m1_n2243_n1314# 0.20937f
C52 NAND3_16/a_n593_982# wl[46] 0.05101f
C53 NAND3_12/a_n593_982# VDD 2.7494f
C54 comp[33] NAND3_29/a_n593_982# 0.05055f
C55 NAND3_30/a_2506_982# wl[32] 1.10339f
C56 NAND3_58/m1_n3706_n1374# comp[3] 0.22408f
C57 comp[51] NAND3_12/m1_n3706_n1374# 0.21268f
C58 NAND3_13/m1_n3706_n1374# NAND3_12/m1_n3706_n1374# 0.05965f
C59 NAND3_46/a_n593_982# NAND3_46/a_2506_982# 1.12155f
C60 NAND3_23/m1_n3706_n1374# NAND3_23/m1_n2243_n1314# 0.9315f
C61 NAND3_20/a_n593_982# wl[42] 0.05101f
C62 wl[47] VDD 2.04642f
C63 NAND3_20/a_n593_982# comp[43] 1.40214f
C64 comp[11] NAND3_51/a_n593_982# 0.05055f
C65 wl[5] NAND3_57/a_2506_982# 1.10339f
C66 comp[53] comp[54] 1.35332f
C67 comp[57] NAND3_5/m1_n3706_n1374# 0.37536f
C68 comp[43] NAND3_18/m1_n3706_n1374# 0.19865f
C69 wl[47] NAND3_15/a_n593_982# 0.05101f
C70 comp[54] NAND3_9/m1_n3706_n1374# 0.26395f
C71 NAND3_9/m1_n2243_n1314# NAND3_8/m1_n2243_n1314# 0.05788f
C72 comp[21] NAND3_41/m1_n3706_n1374# 0.37536f
C73 NAND3_62/a_n593_982# comp[1] 1.40214f
C74 comp[4] NAND3_59/m1_n3706_n1374# 0.2157f
C75 comp[23] VDD 2.90414f
C76 comp[12] NAND3_50/m1_n2243_n1314# 0.16299f
C77 comp[41] NAND3_22/m1_n2243_n1314# 0.20937f
C78 NAND3_57/a_2506_982# comp[4] 1.03779f
C79 comp[23] NAND3_40/a_n593_982# 1.40214f
C80 NAND3_35/a_n593_982# VDD 2.7494f
C81 comp[42] NAND3_21/m1_n3706_n1374# 0.26395f
C82 NAND3_41/m1_n3706_n1374# NAND3_40/m1_n3706_n1374# 0.05965f
C83 NAND3_18/a_2506_982# wl[44] 1.10339f
C84 comp[6] NAND3_57/a_2506_982# 0.34787f
C85 comp[45] NAND3_17/m1_n2243_n1314# 0.16299f
C86 comp[46] NAND3_16/a_n593_982# 0.05055f
C87 NAND3_56/a_2506_982# comp[6] 0.9579f
C88 NAND3_31/a_n593_982# comp[31] 0.05055f
C89 comp[29] NAND3_34/a_2506_982# 0.31189f
C90 NAND3_44/a_n593_982# VDD 2.7494f
C91 comp[61] NAND3_1/a_n593_982# 0.05055f
C92 comp[4] comp[5] 2.51881f
C93 NAND3_32/a_n593_982# NAND3_32/a_2506_982# 1.12155f
C94 comp[9] VDD 3.15765f
C95 comp[22] NAND3_41/m1_n3706_n1374# 0.2157f
C96 NAND3_19/m1_n3706_n1374# comp[43] 0.34993f
C97 comp[23] NAND3_38/m1_n3706_n1374# 0.17481f
C98 comp[40] NAND3_22/a_n593_982# 0.05055f
C99 NAND3_21/a_2506_982# NAND3_21/m1_n3706_n1374# 0.86518f
C100 wl[35] NAND3_27/a_2506_982# 1.10339f
C101 NAND3_25/a_n593_982# comp[38] 1.40214f
C102 comp[15] NAND3_48/m1_n3706_n1374# 0.21268f
C103 comp[6] comp[5] 1.35332f
C104 comp[36] NAND3_26/a_2506_982# 0.9579f
C105 wl[7] VDD 2.04642f
C106 NAND3_15/m1_n2243_n1314# NAND3_15/a_n593_982# 0.33989f
C107 comp[54] NAND3_8/a_n593_982# 0.05055f
C108 comp[22] NAND3_39/m1_n3706_n1374# 0.17282f
C109 comp[26] comp[24] 0.08982f
C110 NAND3_43/a_n593_982# comp[19] 0.05055f
C111 comp[11] NAND3_50/m1_n3706_n1374# 0.17481f
C112 comp[55] NAND3_7/m1_n2243_n1314# 0.16299f
C113 NAND3_48/a_2506_982# VDD 6.45473f
C114 NAND3_62/a_n593_982# m1_n4168_2156# 0.05055f
C115 NAND3_51/a_n593_982# wl[11] 0.05101f
C116 NAND3_17/m1_n3706_n1374# NAND3_16/m1_n3706_n1374# 0.05965f
C117 NAND3_1/a_n593_982# VDD 2.7494f
C118 NAND3_10/a_2506_982# VDD 6.45473f
C119 comp[42] comp[41] 1.35332f
C120 NAND3_4/m1_n2243_n1314# NAND3_4/m1_n3706_n1374# 0.9315f
C121 NAND3_56/m1_n2243_n1314# NAND3_57/m1_n2243_n1314# 0.05788f
C122 NAND3_58/m1_n2243_n1314# comp[4] 0.16299f
C123 NAND3_23/a_n593_982# VDD 2.7494f
C124 NAND3_50/a_n593_982# VDD 2.7494f
C125 NAND3_25/m1_n3706_n1374# NAND3_24/m1_n3706_n1374# 0.05965f
C126 wl[38] VDD 2.04641f
C127 NAND3_33/a_n593_982# NAND3_33/a_2506_982# 1.12155f
C128 comp[2] NAND3_61/m1_n2243_n1314# 0.20948f
C129 NAND3_21/m1_n3706_n1374# NAND3_20/m1_n3706_n1374# 0.05965f
C130 NAND3_5/a_n593_982# comp[57] 0.05055f
C131 NAND3_11/a_n593_982# VDD 2.7494f
C132 NAND3_49/a_n593_982# NAND3_49/a_2506_982# 1.12155f
C133 comp[1] NAND3_60/m1_n3706_n1374# 0.19865f
C134 NAND3_21/a_2506_982# comp[41] 0.80459f
C135 comp[28] NAND3_35/a_n593_982# 1.40214f
C136 comp[7] VDD 2.9108f
C137 comp[33] NAND3_30/a_n593_982# 1.40214f
C138 NAND3_62/m1_n3706_n1374# comp[1] 0.21268f
C139 NAND3_50/a_n593_982# NAND3_50/a_2506_982# 1.12155f
C140 NAND3_49/a_n593_982# VDD 2.7494f
C141 NAND3_35/m1_n3706_n1374# comp[27] 0.37536f
C142 NAND3_61/m1_n3706_n1374# NAND3_60/m1_n3706_n1374# 0.05965f
C143 comp[55] NAND3_8/m1_n3706_n1374# 0.21268f
C144 NAND3_59/m1_n2243_n1314# NAND3_59/m1_n3706_n1374# 0.9315f
C145 wl[6] VDD 2.04641f
C146 NAND3_11/a_2506_982# VDD 6.45473f
C147 NAND3_4/a_n593_982# comp[59] 1.40214f
C148 NAND3_52/a_n593_982# comp[11] 1.40214f
C149 wl[0] VDD 2.04641f
C150 comp[9] NAND3_54/a_2506_982# 0.42758f
C151 NAND3_20/m1_n3706_n1374# comp[41] 0.17481f
C152 comp[45] VDD 3.15765f
C153 comp[20] comp[18] 0.08982f
C154 wl[36] NAND3_26/a_n593_982# 0.05101f
C155 NAND3_13/a_n593_982# wl[49] 0.05101f
C156 comp[12] NAND3_49/m1_n3706_n1374# 0.17282f
C157 NAND3_24/m1_n3706_n1374# comp[37] 0.19865f
C158 NAND3_19/a_n593_982# wl[43] 0.05101f
C159 NAND3_34/a_n593_982# NAND3_34/a_2506_982# 1.12155f
C160 comp[32] VDD 2.90414f
C161 comp[53] NAND3_9/a_n593_982# 0.05055f
C162 comp[18] NAND3_44/m1_n2243_n1314# 0.16299f
C163 NAND3_41/m1_n3706_n1374# comp[20] 0.17282f
C164 NAND3_45/a_2506_982# NAND3_45/a_n593_982# 1.12155f
C165 comp[42] VDD 3.15765f
C166 comp[36] VDD 3.15765f
C167 NAND3_62/m1_n3706_n1374# m1_n4168_2156# 0.3238f
C168 NAND3_43/m1_n3706_n1374# NAND3_43/m1_n2243_n1314# 0.9315f
C169 NAND3_17/m1_n3706_n1374# comp[46] 0.2157f
C170 comp[50] NAND3_12/m1_n2243_n1314# 0.16299f
C171 NAND3_6/a_n593_982# NAND3_6/a_2506_982# 1.12155f
C172 NAND3_1/m1_n2243_n1314# NAND3_1/a_n593_982# 0.33989f
C173 comp[53] comp[55] 0.44143f
C174 NAND3_35/m1_n2243_n1314# NAND3_35/m1_n3706_n1374# 0.9315f
C175 comp[29] NAND3_34/m1_n3706_n1374# 0.21268f
C176 NAND3_21/a_2506_982# VDD 6.45473f
C177 NAND3_23/m1_n3706_n1374# comp[40] 0.2157f
C178 comp[2] NAND3_60/a_n593_982# 0.05055f
C179 wl[18] NAND3_44/a_n593_982# 0.05101f
C180 comp[17] VDD 2.90414f
C181 comp[46] NAND3_15/a_2506_982# 1.03779f
C182 NAND3_57/a_n593_982# NAND3_57/a_2506_982# 1.12155f
C183 wl[33] NAND3_29/a_2506_982# 1.10339f
C184 wl[30] VDD 2.04641f
C185 NAND3_59/m1_n2243_n1314# NAND3_58/m1_n2243_n1314# 0.05788f
C186 comp[16] comp[18] 0.1031f
C187 NAND3_35/m1_n2243_n1314# comp[27] 0.16299f
C188 NAND3_50/m1_n3706_n1374# NAND3_50/m1_n2243_n1314# 0.9315f
C189 NAND3_54/a_2506_982# comp[7] 0.99086f
C190 NAND3_11/m1_n2243_n1314# comp[52] 0.20948f
C191 NAND3_52/a_n593_982# comp[10] 0.05055f
C192 comp[26] NAND3_37/m1_n2243_n1314# 0.20948f
C193 comp[4] NAND3_58/a_n593_982# 0.05055f
C194 NAND3_43/m1_n3706_n1374# NAND3_42/m1_n3706_n1374# 0.05965f
C195 NAND3_28/m1_n3706_n1374# NAND3_28/m1_n2243_n1314# 0.9315f
C196 comp[11] VDD 2.90414f
C197 NAND3_27/m1_n2243_n1314# NAND3_27/m1_n3706_n1374# 0.9315f
C198 NAND3_57/a_n593_982# comp[5] 0.05055f
C199 NAND3_7/a_n593_982# VDD 2.7494f
C200 comp[20] NAND3_43/a_2506_982# 0.30956f
C201 comp[21] NAND3_40/m1_n3706_n1374# 0.22408f
C202 NAND3_30/a_2506_982# comp[32] 0.80389f
C203 NAND3_56/m1_n3706_n1374# NAND3_56/m1_n2243_n1314# 0.9315f
C204 NAND3_49/m1_n3706_n1374# NAND3_48/m1_n3706_n1374# 0.05965f
C205 NAND3_19/m1_n3706_n1374# NAND3_18/m1_n3706_n1374# 0.05965f
C206 NAND3_36/a_2506_982# wl[26] 1.10339f
C207 wl[23] NAND3_39/a_2506_982# 1.10339f
C208 NAND3_52/m1_n2243_n1314# NAND3_53/m1_n2243_n1314# 0.05788f
C209 NAND3_4/a_2506_982# comp[59] 0.31189f
C210 comp[21] comp[22] 2.58001f
C211 NAND3_18/m1_n2243_n1314# NAND3_19/m1_n2243_n1314# 0.05788f
C212 comp[38] NAND3_24/a_2506_982# 0.80389f
C213 comp[29] NAND3_33/a_2506_982# 0.80459f
C214 NAND3_22/a_n593_982# NAND3_22/m1_n2243_n1314# 0.33989f
C215 comp[55] NAND3_8/a_n593_982# 1.40214f
C216 NAND3_36/a_2506_982# NAND3_36/m1_n3706_n1374# 0.86518f
C217 NAND3_3/m1_n3706_n1374# comp[60] 0.26395f
C218 comp[57] comp[59] 0.15406f
C219 NAND3_55/m1_n3706_n1374# comp[8] 0.21467f
C220 comp[11] NAND3_50/a_2506_982# 0.95992f
C221 NAND3_55/a_n593_982# comp[8] 1.40214f
C222 comp[22] NAND3_40/m1_n3706_n1374# 0.32681f
C223 NAND3_18/m1_n2243_n1314# comp[45] 0.20937f
C224 NAND3_7/a_n593_982# comp[56] 1.40214f
C225 comp[42] NAND3_20/m1_n2243_n1314# 0.16299f
C226 comp[2] comp[3] 1.40927f
C227 NAND3_53/m1_n3706_n1374# comp[8] 0.17282f
C228 NAND3_61/a_n593_982# NAND3_61/m1_n2243_n1314# 0.33989f
C229 NAND3_13/a_n593_982# NAND3_13/m1_n2243_n1314# 0.33989f
C230 NAND3_56/a_n593_982# VDD 2.7494f
C231 wl[54] VDD 2.04641f
C232 comp[12] comp[13] 2.50926f
C233 NAND3_60/a_n593_982# wl[2] 0.05101f
C234 NAND3_62/m1_n2243_n1314# comp[1] 0.20937f
C235 NAND3_26/a_2506_982# NAND3_26/m1_n3706_n1374# 0.86518f
C236 NAND3_36/a_2506_982# VDD 6.45473f
C237 comp[10] VDD 3.0571f
C238 NAND3_47/a_2506_982# comp[15] 0.9579f
C239 NAND3_35/a_2506_982# comp[26] 0.96225f
C240 comp[23] NAND3_39/a_2506_982# 0.80459f
C241 comp[36] comp[35] 1.35332f
C242 NAND3_47/m1_n2243_n1314# NAND3_46/m1_n2243_n1314# 0.05788f
C243 comp[32] NAND3_29/m1_n3706_n1374# 0.17282f
C244 NAND3_30/m1_n3706_n1374# comp[31] 0.19865f
C245 wl[11] VDD 2.04642f
C246 wl[28] NAND3_34/a_2506_982# 1.10339f
C247 NAND3_36/a_n593_982# comp[27] 1.40214f
C248 comp[15] VDD 3.15765f
C249 NAND3_25/m1_n3706_n1374# comp[36] 0.17282f
C250 NAND3_18/a_n593_982# VDD 2.7494f
C251 comp[62] NAND3_1/a_2506_982# 0.30956f
C252 comp[16] NAND3_47/m1_n2243_n1314# 0.20948f
C253 NAND3_25/a_2506_982# wl[37] 1.10339f
C254 comp[40] NAND3_22/m1_n3706_n1374# 0.32681f
C255 comp[2] NAND3_60/m1_n2243_n1314# 0.16299f
C256 NAND3_6/a_2506_982# VDD 6.45473f
C257 NAND3_14/m1_n3706_n1374# NAND3_14/m1_n2243_n1314# 0.9315f
C258 NAND3_31/a_n593_982# VDD 2.7494f
C259 NAND3_20/m1_n2243_n1314# NAND3_20/m1_n3706_n1374# 0.9315f
C260 NAND3_6/a_2506_982# NAND3_6/m1_n3706_n1374# 0.86518f
C261 NAND3_24/a_n593_982# comp[39] 1.40214f
C262 comp[47] comp[48] 1.35332f
C263 wl[39] VDD 2.04642f
C264 NAND3_27/a_n593_982# VDD 2.7494f
C265 comp[54] NAND3_9/m1_n2243_n1314# 0.20948f
C266 NAND3_48/m1_n2243_n1314# NAND3_49/m1_n2243_n1314# 0.05788f
C267 NAND3_62/m1_n2243_n1314# m1_n4168_2156# 0.16299f
C268 comp[24] NAND3_38/m1_n2243_n1314# 0.16299f
C269 comp[44] comp[43] 2.57924f
C270 comp[36] NAND3_27/a_2506_982# 0.34787f
C271 NAND3_61/m1_n2243_n1314# comp[1] 0.16299f
C272 NAND3_38/a_2506_982# VDD 6.45473f
C273 NAND3_42/a_2506_982# VDD 6.45473f
C274 comp[21] comp[20] 1.40927f
C275 comp[13] NAND3_48/m1_n3706_n1374# 0.19865f
C276 wl[10] NAND3_52/a_2506_982# 1.10339f
C277 NAND3_17/m1_n3706_n1374# comp[44] 0.17282f
C278 NAND3_46/a_n593_982# VDD 2.7494f
C279 NAND3_5/m1_n2243_n1314# comp[57] 0.16299f
C280 NAND3_10/a_n593_982# NAND3_10/a_2506_982# 1.12155f
C281 comp[56] NAND3_6/a_2506_982# 0.80389f
C282 NAND3_42/a_n593_982# comp[21] 1.40214f
C283 wl[50] NAND3_12/a_n593_982# 0.05101f
C284 NAND3_10/m1_n2243_n1314# NAND3_10/a_n593_982# 0.33989f
C285 wl[58] VDD 2.04641f
C286 comp[23] NAND3_39/m1_n2243_n1314# 0.16299f
C287 NAND3_37/a_n593_982# NAND3_37/m1_n2243_n1314# 0.33989f
C288 comp[36] comp[37] 2.50926f
C289 wl[41] NAND3_21/a_n593_982# 0.05101f
C290 wl[12] VDD 2.04641f
C291 NAND3_38/a_2506_982# NAND3_38/m1_n3706_n1374# 0.86518f
C292 wl[20] NAND3_42/a_2506_982# 1.10339f
C293 NAND3_61/m1_n3706_n1374# NAND3_61/m1_n2243_n1314# 0.9315f
C294 NAND3_42/a_2506_982# NAND3_42/m1_n3706_n1374# 0.86518f
C295 wl[24] VDD 2.04641f
C296 comp[22] comp[20] 0.10075f
C297 NAND3_6/a_n593_982# comp[57] 1.40214f
C298 comp[49] comp[48] 2.50926f
C299 comp[46] NAND3_16/m1_n3706_n1374# 0.32681f
C300 comp[24] VDD 3.15765f
C301 NAND3_58/a_2506_982# comp[4] 0.87927f
C302 wl[12] NAND3_50/a_2506_982# 1.10339f
C303 wl[43] VDD 2.04641f
C304 NAND3_57/a_2506_982# comp[5] 0.80459f
C305 comp[32] comp[34] 0.10075f
C306 comp[54] VDD 3.15765f
C307 NAND3_56/a_2506_982# comp[5] 0.95992f
C308 NAND3_33/a_n593_982# comp[30] 1.40214f
C309 comp[30] NAND3_31/a_2506_982# 1.07676f
C310 comp[3] comp[4] 2.58001f
C311 NAND3_2/m1_n3706_n1374# NAND3_3/m1_n3706_n1374# 0.05965f
C312 NAND3_32/m1_n3706_n1374# comp[30] 0.37506f
C313 NAND3_18/m1_n2243_n1314# NAND3_18/a_n593_982# 0.33989f
C314 NAND3_17/a_2506_982# comp[45] 0.9579f
C315 NAND3_24/a_n593_982# NAND3_24/m1_n2243_n1314# 0.33989f
C316 NAND3_23/a_2506_982# comp[39] 0.9579f
C317 comp[36] comp[34] 0.1031f
C318 comp[50] NAND3_11/m1_n3706_n1374# 0.17282f
C319 comp[24] NAND3_38/m1_n3706_n1374# 0.37506f
C320 NAND3_4/a_n593_982# VDD 2.7494f
C321 NAND3_57/m1_n3706_n1374# NAND3_57/m1_n2243_n1314# 0.9315f
C322 NAND3_14/a_2506_982# comp[48] 0.9579f
C323 NAND3_45/a_2506_982# comp[18] 0.34787f
C324 comp[62] NAND3_0/m1_n3706_n1374# 0.32579f
C325 NAND3_34/m1_n2243_n1314# NAND3_35/m1_n2243_n1314# 0.05788f
C326 NAND3_36/m1_n2243_n1314# NAND3_37/m1_n2243_n1314# 0.05788f
C327 NAND3_53/a_n593_982# VDD 2.7494f
C328 NAND3_62/m1_n2243_n1314# NAND3_62/a_n593_982# 0.33989f
C329 NAND3_34/a_2506_982# VDD 6.45473f
C330 wl[61] NAND3_1/a_n593_982# 0.05101f
C331 comp[54] comp[56] 0.08982f
C332 NAND3_47/a_2506_982# NAND3_47/m1_n3706_n1374# 0.86518f
C333 NAND3_27/a_n593_982# comp[35] 0.05055f
C334 comp[13] NAND3_50/m1_n3706_n1374# 0.21268f
C335 NAND3_29/a_2506_982# VDD 6.45473f
C336 NAND3_49/a_2506_982# NAND3_49/m1_n3706_n1374# 0.86518f
C337 NAND3_25/a_2506_982# VDD 6.45473f
C338 comp[50] comp[48] 0.08982f
C339 NAND3_45/a_n593_982# VDD 2.7494f
C340 NAND3_48/a_n593_982# VDD 2.7494f
C341 NAND3_58/m1_n2243_n1314# comp[5] 0.20937f
C342 comp[53] comp[52] 2.51881f
C343 NAND3_7/m1_n2243_n1314# NAND3_7/m1_n3706_n1374# 0.9315f
C344 comp[47] VDD 2.90414f
C345 NAND3_32/a_n593_982# wl[30] 0.05101f
C346 NAND3_9/m1_n3706_n1374# comp[52] 0.17282f
C347 NAND3_29/m1_n2243_n1314# NAND3_29/a_n593_982# 0.33989f
C348 wl[42] NAND3_20/a_2506_982# 1.10339f
C349 wl[52] NAND3_10/a_2506_982# 1.10339f
C350 NAND3_47/a_n593_982# NAND3_47/m1_n2243_n1314# 0.33989f
C351 NAND3_56/m1_n2243_n1314# comp[7] 0.20937f
C352 comp[43] NAND3_20/a_2506_982# 0.31343f
C353 NAND3_40/a_2506_982# comp[23] 0.31189f
C354 NAND3_37/a_2506_982# comp[25] 0.83727f
C355 comp[47] NAND3_15/a_n593_982# 0.05055f
C356 NAND3_24/a_n593_982# VDD 2.7494f
C357 NAND3_9/a_n593_982# NAND3_9/m1_n2243_n1314# 0.33989f
C358 NAND3_12/a_2506_982# VDD 6.45473f
C359 NAND3_19/a_n593_982# comp[43] 0.05055f
C360 comp[33] NAND3_29/m1_n2243_n1314# 0.16299f
C361 NAND3_27/a_n593_982# NAND3_27/a_2506_982# 1.12155f
C362 NAND3_23/m1_n2243_n1314# comp[40] 0.20948f
C363 NAND3_22/m1_n3706_n1374# NAND3_22/m1_n2243_n1314# 0.9315f
C364 comp[14] NAND3_49/m1_n2243_n1314# 0.20948f
C365 NAND3_42/a_n593_982# comp[20] 0.05055f
C366 comp[3] comp[1] 0.45884f
C367 comp[44] NAND3_18/m1_n3706_n1374# 0.32579f
C368 comp[35] NAND3_26/m1_n3706_n1374# 0.17481f
C369 comp[28] NAND3_34/a_2506_982# 0.87927f
C370 NAND3_28/a_2506_982# NAND3_28/m1_n3706_n1374# 0.86518f
C371 NAND3_32/a_n593_982# NAND3_32/m1_n2243_n1314# 0.33989f
C372 comp[2] VDD 2.90414f
C373 NAND3_15/m1_n3706_n1374# NAND3_15/m1_n2243_n1314# 0.9315f
C374 NAND3_51/m1_n3706_n1374# comp[12] 0.26395f
C375 NAND3_16/m1_n2243_n1314# comp[47] 0.20937f
C376 NAND3_4/a_2506_982# VDD 6.45473f
C377 NAND3_59/m1_n2243_n1314# comp[3] 0.16299f
C378 comp[57] VDD 3.15765f
C379 comp[57] NAND3_6/m1_n3706_n1374# 0.21268f
C380 comp[36] NAND3_26/a_n593_982# 0.05055f
C381 comp[27] NAND3_35/a_n593_982# 0.05055f
C382 comp[49] VDD 2.9108f
C383 NAND3_62/m1_n3706_n1374# NAND3_62/m1_n2243_n1314# 0.9315f
C384 comp[58] NAND3_5/m1_n3706_n1374# 0.2157f
C385 wl[33] NAND3_29/a_n593_982# 0.05101f
C386 NAND3_14/a_n593_982# comp[48] 0.05055f
C387 NAND3_38/a_n593_982# comp[25] 1.40214f
C388 comp[39] NAND3_22/a_2506_982# 0.99962f
C389 wl[51] VDD 2.04642f
C390 comp[33] comp[31] 0.45884f
C391 NAND3_39/a_n593_982# VDD 2.7494f
C392 NAND3_47/a_n593_982# wl[15] 0.05101f
C393 comp[29] comp[30] 1.35332f
C394 NAND3_53/a_n593_982# wl[9] 0.05101f
C395 comp[11] NAND3_51/a_2506_982# 0.80459f
C396 NAND3_19/m1_n3706_n1374# comp[44] 0.21467f
C397 NAND3_56/m1_n3706_n1374# NAND3_57/m1_n3706_n1374# 0.05965f
C398 NAND3_26/m1_n2243_n1314# comp[37] 0.20937f
C399 NAND3_0/a_n593_982# comp[62] 0.05055f
C400 comp[57] comp[56] 1.40927f
C401 NAND3_9/a_n593_982# VDD 2.7494f
C402 NAND3_33/m1_n3706_n1374# NAND3_33/m1_n2243_n1314# 0.9315f
C403 comp[3] NAND3_59/a_n593_982# 0.05055f
C404 comp[45] NAND3_18/a_2506_982# 0.42758f
C405 NAND3_40/m1_n2243_n1314# comp[23] 0.20937f
C406 comp[13] NAND3_49/a_2506_982# 0.83727f
C407 NAND3_14/a_2506_982# VDD 6.45473f
C408 NAND3_23/a_2506_982# VDD 6.45473f
C409 comp[16] NAND3_46/m1_n2243_n1314# 0.16299f
C410 wl[22] VDD 2.04641f
C411 NAND3_53/m1_n3706_n1374# NAND3_52/m1_n3706_n1374# 0.05965f
C412 comp[55] VDD 2.9108f
C413 NAND3_58/a_n593_982# comp[5] 1.40214f
C414 wl[22] NAND3_40/a_n593_982# 0.05101f
C415 comp[55] NAND3_6/m1_n3706_n1374# 0.19865f
C416 NAND3_26/m1_n3706_n1374# comp[37] 0.21268f
C417 NAND3_35/m1_n2243_n1314# NAND3_35/a_n593_982# 0.33989f
C418 NAND3_29/a_2506_982# NAND3_29/m1_n3706_n1374# 0.86518f
C419 comp[14] NAND3_48/m1_n2243_n1314# 0.16299f
C420 NAND3_25/a_2506_982# NAND3_25/m1_n3706_n1374# 0.86518f
C421 comp[13] VDD 2.9108f
C422 NAND3_55/a_n593_982# wl[7] 0.05101f
C423 comp[50] VDD 2.90414f
C424 wl[2] VDD 2.04641f
C425 wl[14] VDD 2.04641f
C426 comp[9] comp[8] 1.40927f
C427 NAND3_35/a_2506_982# VDD 6.45473f
C428 NAND3_53/m1_n3706_n1374# comp[9] 0.37536f
C429 NAND3_12/a_n593_982# comp[51] 1.40214f
C430 comp[38] comp[39] 1.40927f
C431 NAND3_58/m1_n2243_n1314# NAND3_58/a_n593_982# 0.33989f
C432 comp[41] NAND3_22/a_2506_982# 0.31189f
C433 comp[10] NAND3_51/a_2506_982# 1.03779f
C434 comp[55] comp[56] 2.57924f
C435 comp[13] NAND3_50/a_2506_982# 0.31343f
C436 comp[35] NAND3_28/m1_n3706_n1374# 0.21268f
C437 NAND3_16/a_n593_982# VDD 2.7494f
C438 NAND3_5/a_n593_982# comp[58] 1.40214f
C439 wl[5] VDD 2.04642f
C440 comp[45] NAND3_16/a_2506_982# 0.99962f
C441 NAND3_10/m1_n3706_n1374# comp[52] 0.32681f
C442 NAND3_56/m1_n2243_n1314# NAND3_56/a_n593_982# 0.33989f
C443 NAND3_33/a_2506_982# VDD 6.45473f
C444 NAND3_41/a_n593_982# VDD 2.7494f
C445 comp[42] NAND3_19/a_2506_982# 1.07676f
C446 NAND3_17/a_n593_982# comp[46] 1.40214f
C447 NAND3_15/a_2506_982# comp[48] 0.34787f
C448 NAND3_20/a_n593_982# NAND3_20/a_2506_982# 1.12155f
C449 NAND3_30/a_2506_982# NAND3_30/m1_n3706_n1374# 0.86518f
C450 NAND3_29/m1_n3706_n1374# NAND3_28/m1_n3706_n1374# 0.05965f
C451 NAND3_51/a_2506_982# wl[11] 1.10339f
C452 NAND3_45/a_2506_982# wl[17] 1.10339f
C453 NAND3_17/m1_n3706_n1374# NAND3_17/m1_n2243_n1314# 0.9315f
C454 NAND3_55/m1_n3706_n1374# comp[7] 0.34993f
C455 wl[31] NAND3_31/a_2506_982# 1.10339f
C456 wl[13] NAND3_49/a_2506_982# 1.10339f
C457 comp[28] NAND3_34/m1_n3706_n1374# 0.32681f
C458 NAND3_55/a_n593_982# comp[7] 0.05055f
C459 NAND3_13/m1_n3706_n1374# NAND3_13/m1_n2243_n1314# 0.9315f
C460 NAND3_12/a_2506_982# NAND3_12/m1_n3706_n1374# 0.86518f
C461 comp[24] NAND3_39/a_2506_982# 0.34787f
C462 comp[46] comp[44] 0.10075f
C463 NAND3_25/a_2506_982# comp[37] 0.83727f
C464 NAND3_23/m1_n2243_n1314# NAND3_23/a_n593_982# 0.33989f
C465 wl[0] NAND3_62/a_2506_982# 1.10339f
C466 comp[43] comp[41] 0.44143f
C467 NAND3_49/a_n593_982# NAND3_49/m1_n2243_n1314# 0.33989f
C468 comp[8] comp[7] 2.57924f
C469 comp[4] VDD 3.0571f
C470 wl[13] VDD 2.04641f
C471 comp[6] VDD 3.15765f
C472 comp[31] comp[30] 2.50926f
C473 NAND3_16/m1_n2243_n1314# NAND3_16/a_n593_982# 0.33989f
C474 NAND3_54/a_2506_982# NAND3_54/m1_n3706_n1374# 0.86518f
C475 NAND3_35/a_2506_982# comp[28] 0.30956f
C476 NAND3_23/m1_n2243_n1314# NAND3_22/m1_n2243_n1314# 0.05788f
C477 NAND3_61/a_n593_982# VDD 2.7494f
C478 NAND3_14/a_n593_982# VDD 2.7494f
C479 NAND3_51/m1_n3706_n1374# NAND3_50/m1_n3706_n1374# 0.05965f
C480 comp[52] NAND3_11/m1_n3706_n1374# 0.2157f
C481 comp[26] comp[25] 2.57924f
C482 NAND3_12/m1_n3706_n1374# comp[49] 0.19865f
C483 NAND3_29/a_2506_982# comp[34] 0.30956f
C484 comp[28] NAND3_33/a_2506_982# 1.03779f
C485 NAND3_22/a_2506_982# VDD 6.45473f
C486 wl[8] NAND3_54/a_n593_982# 0.05101f
C487 NAND3_7/a_n593_982# NAND3_7/a_2506_982# 1.12155f
C488 comp[38] NAND3_24/m1_n2243_n1314# 0.16299f
C489 NAND3_21/m1_n2243_n1314# NAND3_21/a_n593_982# 0.33989f
C490 NAND3_9/a_2506_982# wl[53] 1.10339f
C491 comp[29] NAND3_33/a_n593_982# 0.05055f
C492 comp[29] NAND3_32/m1_n3706_n1374# 0.17481f
C493 NAND3_26/m1_n2243_n1314# NAND3_26/a_n593_982# 0.33989f
C494 NAND3_4/a_2506_982# NAND3_4/m1_n3706_n1374# 0.86518f
C495 NAND3_46/a_n593_982# wl[16] 0.05101f
C496 NAND3_4/m1_n3706_n1374# comp[57] 0.22408f
C497 NAND3_14/m1_n3706_n1374# comp[47] 0.17481f
C498 comp[18] VDD 3.15765f
C499 comp[51] NAND3_10/a_2506_982# 0.99962f
C500 NAND3_18/a_n593_982# NAND3_18/a_2506_982# 1.12155f
C501 NAND3_44/a_2506_982# VDD 6.45473f
C502 comp[24] NAND3_39/m1_n2243_n1314# 0.20948f
C503 wl[42] VDD 2.04641f
C504 wl[48] VDD 2.04641f
C505 comp[58] NAND3_3/a_2506_982# 1.03779f
C506 comp[61] NAND3_1/a_2506_982# 0.83727f
C507 comp[43] VDD 2.9108f
C508 comp[3] NAND3_60/m1_n3706_n1374# 0.21268f
C509 comp[51] NAND3_11/a_n593_982# 0.05055f
C510 NAND3_54/a_n593_982# VDD 2.7494f
C511 NAND3_52/a_n593_982# wl[10] 0.05101f
C512 wl[1] VDD 2.04642f
C513 NAND3_28/m1_n3706_n1374# comp[34] 0.32681f
C514 comp[16] NAND3_46/a_2506_982# 0.87927f
C515 NAND3_47/a_n593_982# comp[16] 1.40214f
C516 comp[3] NAND3_59/m1_n3706_n1374# 0.37536f
C517 comp[1] VDD 3.00466f
C518 NAND3_18/a_n593_982# wl[44] 0.05101f
C519 comp[50] NAND3_12/m1_n3706_n1374# 0.32579f
C520 NAND3_58/a_2506_982# comp[5] 0.31189f
C521 NAND3_36/a_2506_982# comp[27] 0.42758f
C522 NAND3_44/a_n593_982# comp[19] 1.40214f
C523 NAND3_1/a_2506_982# VDD 6.45473f
C524 comp[38] VDD 2.90414f
C525 comp[58] comp[59] 2.51881f
C526 NAND3_3/m1_n2243_n1314# comp[59] 0.16299f
C527 NAND3_15/a_2506_982# VDD 6.45473f
C528 NAND3_38/m1_n3706_n1374# NAND3_39/m1_n3706_n1374# 0.05965f
C529 comp[35] NAND3_27/m1_n3706_n1374# 0.32609f
C530 comp[3] comp[5] 0.15406f
C531 NAND3_14/m1_n3706_n1374# comp[49] 0.21268f
C532 comp[51] NAND3_11/a_2506_982# 0.9579f
C533 comp[26] NAND3_37/a_2506_982# 0.30956f
C534 NAND3_25/a_n593_982# wl[37] 0.05101f
C535 NAND3_29/a_n593_982# VDD 2.7494f
C536 NAND3_15/a_2506_982# NAND3_15/a_n593_982# 1.12155f
C537 NAND3_13/a_n593_982# comp[49] 0.05055f
C538 comp[53] NAND3_8/m1_n3706_n1374# 0.17481f
C539 NAND3_43/a_2506_982# VDD 6.45473f
C540 NAND3_60/m1_n2243_n1314# NAND3_60/m1_n3706_n1374# 0.9315f
C541 NAND3_3/m1_n2243_n1314# NAND3_3/a_n593_982# 0.33989f
C542 NAND3_9/m1_n3706_n1374# NAND3_8/m1_n3706_n1374# 0.05965f
C543 NAND3_11/m1_n2243_n1314# NAND3_11/m1_n3706_n1374# 0.9315f
C544 m1_n4168_2156# VDD 2.38082f
C545 NAND3_39/a_n593_982# NAND3_39/a_2506_982# 1.12155f
C546 NAND3_56/m1_n3706_n1374# comp[7] 0.21268f
C547 NAND3_32/a_2506_982# wl[30] 1.10339f
C548 NAND3_3/m1_n2243_n1314# NAND3_2/m1_n2243_n1314# 0.05788f
C549 NAND3_59/a_n593_982# VDD 2.7494f
C550 wl[10] VDD 2.04641f
C551 comp[33] VDD 3.15765f
C552 wl[27] VDD 2.04641f
C553 NAND3_13/a_2506_982# comp[48] 1.07676f
C554 comp[16] NAND3_45/a_2506_982# 1.03779f
C555 NAND3_22/a_n593_982# NAND3_22/a_2506_982# 1.12155f
C556 NAND3_57/a_n593_982# VDD 2.7494f
C557 comp[10] comp[8] 0.10075f
C558 comp[33] NAND3_28/a_2506_982# 0.99962f
C559 NAND3_23/a_2506_982# NAND3_23/m1_n3706_n1374# 0.86518f
C560 comp[31] NAND3_31/a_2506_982# 0.83727f
C561 NAND3_27/a_2506_982# NAND3_27/m1_n3706_n1374# 0.86518f
C562 NAND3_14/a_2506_982# NAND3_14/m1_n3706_n1374# 0.86518f
C563 NAND3_20/m1_n2243_n1314# comp[43] 0.20937f
C564 NAND3_1/a_2506_982# comp[60] 1.07676f
C565 comp[31] NAND3_32/m1_n3706_n1374# 0.21268f
C566 NAND3_54/a_n593_982# NAND3_54/a_2506_982# 1.12155f
C567 NAND3_53/m1_n3706_n1374# comp[10] 0.2157f
C568 comp[53] NAND3_9/m1_n3706_n1374# 0.32609f
C569 NAND3_37/a_n593_982# comp[25] 0.05055f
C570 NAND3_55/a_2506_982# VDD 6.45473f
C571 NAND3_23/a_n593_982# comp[40] 1.40214f
C572 comp[61] NAND3_0/m1_n3706_n1374# 0.19865f
C573 comp[50] NAND3_13/a_n593_982# 1.40214f
C574 NAND3_31/m1_n2243_n1314# comp[31] 0.16299f
C575 NAND3_41/m1_n2243_n1314# NAND3_41/a_n593_982# 0.33989f
C576 comp[52] VDD 3.0571f
C577 NAND3_19/a_2506_982# wl[43] 1.10339f
C578 comp[14] NAND3_48/a_2506_982# 0.80389f
C579 comp[19] NAND3_44/m1_n3706_n1374# 0.21268f
C580 wl[50] NAND3_12/a_2506_982# 1.10339f
C581 wl[18] NAND3_44/a_2506_982# 1.10339f
C582 NAND3_53/a_2506_982# VDD 6.45473f
C583 NAND3_41/a_2506_982# NAND3_41/a_n593_982# 1.12155f
C584 comp[40] NAND3_22/m1_n2243_n1314# 0.16299f
C585 NAND3_30/a_2506_982# comp[33] 0.42758f
C586 comp[11] NAND3_51/m1_n2243_n1314# 0.16299f
C587 comp[58] NAND3_5/m1_n2243_n1314# 0.20948f
C588 wl[41] VDD 2.04642f
C589 wl[21] VDD 2.04642f
C590 NAND3_39/a_n593_982# NAND3_39/m1_n2243_n1314# 0.33989f
C591 comp[54] NAND3_7/a_2506_982# 1.07676f
C592 NAND3_3/a_2506_982# wl[59] 1.10339f
C593 wl[56] NAND3_6/a_2506_982# 1.10339f
C594 NAND3_47/a_2506_982# wl[15] 1.10339f
C595 NAND3_20/a_n593_982# VDD 2.7494f
C596 NAND3_59/a_n593_982# wl[3] 0.05101f
C597 NAND3_43/m1_n3706_n1374# comp[19] 0.34993f
C598 comp[9] NAND3_52/m1_n3706_n1374# 0.22408f
C599 comp[34] NAND3_27/m1_n3706_n1374# 0.17282f
C600 comp[38] NAND3_25/m1_n3706_n1374# 0.21467f
C601 NAND3_62/a_n593_982# VDD 2.7494f
C602 comp[46] comp[48] 0.1031f
C603 comp[17] comp[19] 0.44143f
C604 NAND3_49/a_n593_982# comp[14] 1.40214f
C605 wl[15] VDD 2.04642f
C606 comp[21] VDD 3.15765f
C607 NAND3_58/a_2506_982# NAND3_58/a_n593_982# 1.12155f
C608 NAND3_36/a_2506_982# NAND3_36/a_n593_982# 1.12155f
C609 comp[47] NAND3_15/m1_n3706_n1374# 0.32609f
C610 NAND3_25/a_n593_982# VDD 2.7494f
C611 comp[27] NAND3_34/a_2506_982# 0.99962f
C612 comp[15] NAND3_48/m1_n2243_n1314# 0.20937f
C613 comp[42] comp[40] 0.1031f
C614 wl[17] VDD 2.04642f
C615 NAND3_30/a_n593_982# VDD 2.7494f
C616 comp[33] comp[35] 0.15406f
C617 NAND3_37/a_n593_982# NAND3_37/a_2506_982# 1.12155f
C618 comp[47] NAND3_16/a_2506_982# 0.31189f
C619 comp[32] NAND3_31/m1_n3706_n1374# 0.21467f
C620 NAND3_14/m1_n2243_n1314# NAND3_15/m1_n2243_n1314# 0.05788f
C621 comp[46] NAND3_17/m1_n2243_n1314# 0.20948f
C622 NAND3_3/a_n593_982# wl[59] 0.05101f
C623 NAND3_33/a_2506_982# NAND3_33/m1_n3706_n1374# 0.86518f
C624 comp[30] VDD 3.15765f
C625 comp[39] NAND3_24/a_2506_982# 0.42758f
C626 comp[21] NAND3_42/m1_n3706_n1374# 0.21268f
C627 NAND3_5/m1_n2243_n1314# NAND3_5/m1_n3706_n1374# 0.9315f
C628 comp[40] NAND3_21/a_2506_982# 1.03779f
C629 comp[33] NAND3_29/m1_n3706_n1374# 0.37536f
C630 NAND3_38/m1_n2243_n1314# comp[25] 0.20937f
C631 comp[22] VDD 3.0571f
C632 comp[22] NAND3_40/a_n593_982# 0.05055f
C633 NAND3_13/a_2506_982# VDD 6.45473f
C634 comp[29] NAND3_34/a_n593_982# 1.40214f
C635 comp[38] comp[37] 2.57924f
C636 NAND3_41/m1_n3706_n1374# NAND3_41/m1_n2243_n1314# 0.9315f
C637 comp[29] comp[31] 0.44143f
C638 NAND3_36/m1_n3706_n1374# comp[25] 0.19865f
C639 NAND3_43/a_n593_982# NAND3_43/a_2506_982# 1.12155f
C640 NAND3_7/m1_n3706_n1374# NAND3_6/m1_n3706_n1374# 0.05965f
C641 wl[54] NAND3_8/a_2506_982# 1.10339f
C642 wl[46] VDD 2.04641f
C643 NAND3_53/a_2506_982# wl[9] 1.10339f
C644 NAND3_20/m1_n2243_n1314# NAND3_20/a_n593_982# 0.33989f
C645 NAND3_52/a_n593_982# NAND3_52/m1_n2243_n1314# 0.33989f
C646 NAND3_41/a_2506_982# NAND3_41/m1_n3706_n1374# 0.86518f
C647 NAND3_19/a_n593_982# comp[44] 1.40214f
C648 NAND3_30/a_2506_982# NAND3_30/a_n593_982# 1.12155f
C649 comp[9] comp[7] 0.45884f
C650 comp[53] NAND3_10/m1_n3706_n1374# 0.21268f
C651 NAND3_62/m1_n3706_n1374# VDD 0.17282f
C652 comp[2] NAND3_60/a_2506_982# 0.80389f
C653 NAND3_49/m1_n3706_n1374# NAND3_49/m1_n2243_n1314# 0.9315f
C654 NAND3_57/a_2506_982# VDD 6.45473f
C655 comp[56] NAND3_7/m1_n3706_n1374# 0.21467f
C656 comp[25] VDD 2.9108f
C657 comp[28] comp[30] 0.1031f
C658 NAND3_0/a_n593_982# VDD 2.74492f
C659 NAND3_51/m1_n2243_n1314# NAND3_50/m1_n2243_n1314# 0.05788f
C660 NAND3_18/m1_n2243_n1314# NAND3_18/m1_n3706_n1374# 0.9315f
C661 NAND3_16/m1_n2243_n1314# NAND3_16/m1_n3706_n1374# 0.9315f
C662 NAND3_56/a_2506_982# VDD 6.45473f
C663 NAND3_39/a_2506_982# NAND3_39/m1_n3706_n1374# 0.86518f
C664 NAND3_17/a_2506_982# NAND3_17/m1_n3706_n1374# 0.86518f
C665 comp[2] NAND3_59/a_2506_982# 0.96225f
C666 wl[22] NAND3_40/a_2506_982# 1.10339f
C667 comp[6] NAND3_56/m1_n2243_n1314# 0.16299f
C668 NAND3_23/m1_n3706_n1374# comp[38] 0.17282f
C669 NAND3_29/m1_n2243_n1314# NAND3_28/m1_n2243_n1314# 0.05788f
C670 NAND3_61/m1_n2243_n1314# NAND3_60/m1_n2243_n1314# 0.05788f
C671 comp[5] VDD 2.90414f
C672 NAND3_21/a_n593_982# comp[41] 0.05055f
C673 NAND3_29/a_n593_982# comp[34] 1.40214f
C674 comp[25] NAND3_38/m1_n3706_n1374# 0.21268f
C675 NAND3_5/a_n593_982# NAND3_5/m1_n2243_n1314# 0.33989f
C676 NAND3_3/a_2506_982# comp[59] 0.80459f
C677 wl[35] NAND3_27/a_n593_982# 0.05101f
C678 wl[62] NAND3_0/a_n593_982# 0.05101f
C679 NAND3_35/m1_n3706_n1374# NAND3_34/m1_n3706_n1374# 0.05965f
C680 comp[58] VDD 3.0571f
C681 comp[20] NAND3_43/m1_n2243_n1314# 0.20948f
C682 comp[46] VDD 3.0571f
C683 NAND3_3/a_2506_982# NAND3_3/a_n593_982# 1.12155f
C684 comp[11] NAND3_52/m1_n3706_n1374# 0.21268f
C685 comp[20] VDD 2.90414f
C686 comp[33] comp[34] 2.58001f
C687 comp[55] NAND3_7/a_2506_982# 0.83727f
C688 comp[27] NAND3_34/m1_n3706_n1374# 0.22408f
C689 comp[19] NAND3_42/a_2506_982# 0.99086f
C690 comp[3] NAND3_60/a_n593_982# 1.40214f
C691 NAND3_11/a_n593_982# NAND3_11/a_2506_982# 1.12155f
C692 comp[8] NAND3_54/m1_n2243_n1314# 0.16299f
C693 NAND3_42/a_n593_982# VDD 2.7494f
C694 NAND3_35/m1_n3706_n1374# NAND3_35/a_2506_982# 0.86518f
C695 NAND3_61/a_2506_982# comp[2] 0.30956f
C696 NAND3_48/a_n593_982# NAND3_48/m1_n2243_n1314# 0.33989f
C697 NAND3_22/a_2506_982# NAND3_22/m1_n3706_n1374# 0.86518f
C698 wl[57] NAND3_5/a_n593_982# 0.05101f
C699 comp[58] comp[56] 0.10075f
C700 NAND3_55/a_n593_982# NAND3_55/m1_n2243_n1314# 0.33989f
C701 NAND3_55/m1_n3706_n1374# NAND3_55/m1_n2243_n1314# 0.9315f
C702 NAND3_47/a_2506_982# comp[16] 0.30956f
C703 NAND3_21/m1_n2243_n1314# NAND3_21/m1_n3706_n1374# 0.9315f
C704 comp[20] NAND3_42/m1_n3706_n1374# 0.32579f
C705 NAND3_39/m1_n3706_n1374# NAND3_39/m1_n2243_n1314# 0.9315f
C706 NAND3_3/a_n593_982# comp[59] 0.05055f
C707 wl[2] NAND3_60/a_2506_982# 1.10339f
C708 NAND3_35/a_2506_982# comp[27] 0.9579f
C709 comp[11] comp[9] 0.15406f
C710 NAND3_52/a_n593_982# NAND3_52/a_2506_982# 1.12155f
C711 NAND3_16/a_n593_982# NAND3_16/a_2506_982# 1.12155f
C712 comp[15] comp[14] 1.40927f
C713 NAND3_31/a_2506_982# VDD 6.45473f
C714 NAND3_6/m1_n2243_n1314# comp[57] 0.20937f
C715 comp[8] NAND3_55/m1_n2243_n1314# 0.20948f
C716 NAND3_33/a_n593_982# VDD 2.7494f
C717 NAND3_42/a_n593_982# wl[20] 0.05101f
C718 NAND3_17/a_n593_982# NAND3_17/m1_n2243_n1314# 0.33989f
C719 NAND3_24/a_2506_982# VDD 6.45473f
C720 comp[12] NAND3_51/a_n593_982# 1.40214f
C721 comp[46] NAND3_16/m1_n2243_n1314# 0.16299f
C722 NAND3_37/a_2506_982# VDD 6.45473f
C723 comp[54] NAND3_8/a_2506_982# 0.9579f
C724 NAND3_38/m1_n2243_n1314# NAND3_38/a_n593_982# 0.33989f
C725 NAND3_54/m1_n3706_n1374# NAND3_55/m1_n3706_n1374# 0.05965f
C726 comp[58] comp[60] 0.1031f
C727 comp[16] VDD 3.0571f
C728 NAND3_58/a_2506_982# comp[3] 0.99962f
C729 NAND3_3/m1_n2243_n1314# comp[60] 0.20948f
C730 NAND3_21/a_n593_982# VDD 2.7494f
C731 wl[61] NAND3_1/a_2506_982# 1.10339f
C732 NAND3_60/a_n593_982# NAND3_60/m1_n2243_n1314# 0.33989f
C733 NAND3_25/m1_n2243_n1314# comp[38] 0.20948f
C734 NAND3_25/a_n593_982# comp[37] 0.05055f
C735 comp[51] NAND3_12/a_2506_982# 0.42758f
C736 NAND3_54/m1_n3706_n1374# comp[8] 0.32579f
C737 comp[13] NAND3_49/m1_n2243_n1314# 0.16299f
C738 wl[40] NAND3_22/a_2506_982# 1.10339f
C739 comp[10] NAND3_52/m1_n3706_n1374# 0.32681f
C740 wl[21] NAND3_41/a_2506_982# 1.10339f
C741 NAND3_10/a_n593_982# comp[52] 0.05055f
C742 NAND3_4/m1_n2243_n1314# NAND3_4/a_n593_982# 0.33989f
C743 NAND3_21/m1_n2243_n1314# comp[41] 0.16299f
C744 comp[17] NAND3_46/m1_n3706_n1374# 0.21268f
C745 NAND3_37/a_n593_982# comp[26] 1.40214f
C746 comp[21] NAND3_41/m1_n2243_n1314# 0.16299f
C747 comp[57] NAND3_5/a_2506_982# 0.9579f
C748 comp[62] comp[61] 2.48583f
C749 comp[53] NAND3_9/m1_n2243_n1314# 0.16299f
C750 comp[43] NAND3_18/a_2506_982# 0.99086f
C751 NAND3_5/m1_n3706_n1374# comp[56] 0.17282f
C752 comp[54] NAND3_9/a_2506_982# 0.34787f
C753 NAND3_9/m1_n3706_n1374# NAND3_9/m1_n2243_n1314# 0.9315f
C754 comp[9] comp[10] 2.58001f
C755 NAND3_7/m1_n2243_n1314# comp[56] 0.20948f
C756 comp[51] comp[49] 0.45884f
C757 NAND3_52/a_2506_982# VDD 6.45473f
C758 comp[21] NAND3_41/a_2506_982# 0.9579f
C759 NAND3_51/a_2506_982# NAND3_51/m1_n3706_n1374# 0.86518f
C760 NAND3_38/a_n593_982# VDD 2.7494f
C761 NAND3_13/m1_n3706_n1374# comp[49] 0.34993f
C762 comp[4] NAND3_59/a_2506_982# 0.30956f
C763 comp[17] NAND3_44/m1_n3706_n1374# 0.17481f
C764 comp[12] NAND3_50/m1_n3706_n1374# 0.37506f
C765 NAND3_45/m1_n3706_n1374# NAND3_44/m1_n3706_n1374# 0.05965f
C766 comp[24] NAND3_37/m1_n3706_n1374# 0.17282f
C767 wl[31] VDD 2.04642f
C768 comp[42] NAND3_21/a_2506_982# 0.34787f
C769 comp[62] VDD 1.92617f
C770 comp[22] NAND3_41/m1_n2243_n1314# 0.20948f
C771 NAND3_58/a_n593_982# VDD 2.7494f
C772 comp[3] NAND3_60/m1_n2243_n1314# 0.20937f
C773 comp[6] NAND3_55/m1_n3706_n1374# 0.17282f
C774 comp[22] NAND3_41/a_2506_982# 0.30956f
C775 NAND3_19/a_2506_982# comp[43] 0.83727f
C776 comp[23] NAND3_38/a_2506_982# 0.95992f
C777 wl[59] VDD 2.04641f
C778 comp[15] NAND3_48/a_2506_982# 0.42758f
C779 NAND3_5/a_n593_982# VDD 2.7494f
C780 comp[6] comp[8] 0.08982f
C781 comp[17] NAND3_45/m1_n2243_n1314# 0.16299f
C782 NAND3_32/a_n593_982# comp[30] 0.05055f
C783 comp[22] NAND3_39/a_2506_982# 1.03779f
C784 NAND3_17/a_n593_982# VDD 2.7494f
C785 NAND3_56/a_n593_982# comp[7] 1.40214f
C786 NAND3_45/m1_n3706_n1374# NAND3_45/m1_n2243_n1314# 0.9315f
C787 NAND3_1/a_2506_982# NAND3_1/m1_n3706_n1374# 0.86518f
C788 wl[19] NAND3_43/a_2506_982# 1.10339f
C789 NAND3_36/m1_n2243_n1314# comp[26] 0.16299f
C790 NAND3_45/m1_n3706_n1374# comp[17] 0.32609f
C791 NAND3_34/a_n593_982# wl[28] 0.05101f
C792 NAND3_10/m1_n3706_n1374# NAND3_11/m1_n3706_n1374# 0.05965f
C793 NAND3_13/a_n593_982# NAND3_13/a_2506_982# 1.12155f
C794 comp[42] NAND3_20/m1_n3706_n1374# 0.37506f
C795 comp[6] NAND3_57/m1_n2243_n1314# 0.20948f
C796 NAND3_15/a_2506_982# NAND3_15/m1_n3706_n1374# 0.86518f
C797 comp[44] VDD 2.90414f
C798 wl[6] NAND3_56/a_n593_982# 0.05101f
C799 comp[50] comp[51] 1.40927f
C800 comp[50] NAND3_13/m1_n3706_n1374# 0.21467f
C801 comp[53] VDD 2.90414f
C802 NAND3_23/a_n593_982# wl[39] 0.05101f
C803 comp[20] NAND3_43/a_n593_982# 1.40214f
C804 comp[29] VDD 2.90414f
C805 wl[29] NAND3_33/a_2506_982# 1.10339f
C806 comp[23] comp[24] 1.35332f
C807 comp[62] comp[60] 0.08982f
C808 comp[1] NAND3_60/a_2506_982# 0.99086f
C809 comp[58] NAND3_4/m1_n3706_n1374# 0.32681f
C810 NAND3_47/a_2506_982# NAND3_47/a_n593_982# 1.12155f
C811 NAND3_48/a_n593_982# comp[14] 0.05055f
C812 comp[15] NAND3_46/m1_n3706_n1374# 0.22408f
C813 NAND3_61/a_2506_982# NAND3_61/a_n593_982# 1.12155f
C814 comp[30] NAND3_33/m1_n3706_n1374# 0.26395f
C815 NAND3_47/m1_n3706_n1374# comp[14] 0.17282f
C816 NAND3_62/a_2506_982# comp[1] 0.314f
C817 comp[14] NAND3_49/m1_n3706_n1374# 0.21467f
C818 NAND3_50/a_n593_982# NAND3_50/m1_n2243_n1314# 0.33989f
C819 NAND3_46/a_2506_982# VDD 6.45473f
C820 NAND3_47/a_n593_982# VDD 2.7494f
C821 NAND3_36/m1_n3706_n1374# comp[26] 0.32579f
C822 comp[62] NAND3_1/m1_n2243_n1314# 0.20948f
C823 comp[55] NAND3_8/a_2506_982# 0.31343f
C824 NAND3_25/m1_n2243_n1314# NAND3_25/a_n593_982# 0.33989f
C825 NAND3_12/a_n593_982# NAND3_12/a_2506_982# 1.12155f
C826 NAND3_0/a_2506_982# NAND3_0/m1_n3706_n1374# 0.86518f
C827 NAND3_54/a_n593_982# comp[8] 0.05055f
C828 NAND3_50/a_n593_982# wl[12] 0.05101f
C829 NAND3_18/a_n593_982# comp[45] 1.40214f
C830 NAND3_20/a_2506_982# comp[41] 0.95992f
C831 NAND3_8/a_n593_982# VDD 2.7494f
C832 NAND3_34/m1_n2243_n1314# NAND3_34/m1_n3706_n1374# 0.9315f
C833 comp[12] NAND3_49/a_2506_982# 1.07676f
C834 NAND3_24/a_2506_982# comp[37] 0.99086f
C835 NAND3_31/a_n593_982# comp[32] 1.40214f
C836 comp[29] comp[28] 2.51881f
C837 NAND3_41/a_2506_982# comp[20] 0.96225f
C838 NAND3_21/m1_n2243_n1314# NAND3_20/m1_n2243_n1314# 0.05788f
C839 NAND3_27/m1_n2243_n1314# comp[35] 0.16299f
C840 comp[26] VDD 2.90414f
C841 NAND3_62/a_2506_982# m1_n4168_2156# 0.91884f
C842 NAND3_60/a_n593_982# VDD 2.7494f
C843 NAND3_4/m1_n3706_n1374# NAND3_5/m1_n3706_n1374# 0.05965f
C844 NAND3_9/a_n593_982# NAND3_9/a_2506_982# 1.12155f
C845 NAND3_32/m1_n2243_n1314# NAND3_33/m1_n2243_n1314# 0.05788f
C846 NAND3_17/a_2506_982# comp[46] 0.30956f
C847 NAND3_37/m1_n3706_n1374# NAND3_37/m1_n2243_n1314# 0.9315f
C848 comp[9] NAND3_53/a_n593_982# 0.05055f
C849 NAND3_61/a_2506_982# wl[1] 1.10339f
C850 comp[12] VDD 3.15765f
C851 NAND3_27/a_n593_982# comp[36] 1.40214f
C852 NAND3_3/a_2506_982# VDD 6.45473f
C853 comp[11] comp[10] 2.51881f
C854 comp[61] comp[59] 0.44143f
C855 NAND3_61/a_2506_982# comp[1] 0.83727f
C856 NAND3_18/a_2506_982# NAND3_18/m1_n3706_n1374# 0.86518f
C857 comp[17] comp[15] 0.15406f
C858 NAND3_59/a_n593_982# NAND3_59/a_2506_982# 1.12155f
C859 NAND3_1/m1_n3706_n1374# NAND3_0/m1_n3706_n1374# 0.05965f
C860 NAND3_23/a_2506_982# comp[40] 0.30956f
C861 comp[54] NAND3_8/m1_n2243_n1314# 0.16299f
C862 NAND3_18/m1_n2243_n1314# comp[44] 0.16299f
C863 wl[23] NAND3_39/a_n593_982# 0.05101f
C864 NAND3_45/a_2506_982# VDD 6.45473f
C865 NAND3_9/a_n593_982# wl[53] 0.05101f
C866 comp[47] NAND3_15/m1_n2243_n1314# 0.16299f
C867 comp[12] NAND3_50/a_2506_982# 0.9579f
C868 NAND3_30/m1_n3706_n1374# NAND3_31/m1_n3706_n1374# 0.05965f
C869 wl[55] VDD 2.04642f
C870 NAND3_57/m1_n3706_n1374# comp[4] 0.17282f
C871 comp[59] VDD 2.90414f
C872 NAND3_26/m1_n2243_n1314# comp[36] 0.16299f
C873 comp[6] NAND3_57/m1_n3706_n1374# 0.26395f
C874 NAND3_61/a_2506_982# NAND3_61/m1_n3706_n1374# 0.86518f
C875 NAND3_34/a_n593_982# VDD 2.7494f
C876 NAND3_48/a_n593_982# NAND3_48/a_2506_982# 1.12155f
C877 comp[49] NAND3_13/m1_n2243_n1314# 0.16299f
C878 NAND3_56/m1_n3706_n1374# comp[6] 0.37506f
C879 comp[31] VDD 2.9108f
C880 comp[61] NAND3_2/m1_n2243_n1314# 0.20937f
C881 NAND3_53/m1_n3706_n1374# NAND3_53/m1_n2243_n1314# 0.9315f
C882 comp[21] NAND3_40/a_2506_982# 0.99962f
C883 NAND3_58/a_2506_982# VDD 6.45473f
C884 NAND3_20/a_2506_982# VDD 6.45473f
C885 NAND3_46/a_n593_982# comp[17] 1.40214f
C886 NAND3_3/a_n593_982# VDD 2.7494f
C887 NAND3_55/a_2506_982# NAND3_55/m1_n3706_n1374# 0.86518f
C888 NAND3_61/a_2506_982# m1_n4168_2156# 1.07676f
C889 NAND3_55/a_2506_982# NAND3_55/a_n593_982# 1.12155f
C890 wl[33] VDD 2.04642f
C891 comp[36] NAND3_26/m1_n3706_n1374# 0.37506f
C892 comp[28] comp[26] 0.10075f
C893 NAND3_12/m1_n2243_n1314# NAND3_12/m1_n3706_n1374# 0.9315f
C894 comp[13] comp[14] 2.57924f
C895 NAND3_57/a_n593_982# NAND3_57/m1_n2243_n1314# 0.33989f
C896 comp[3] VDD 3.15765f
C897 NAND3_3/a_2506_982# comp[60] 0.34787f
C898 NAND3_40/a_2506_982# NAND3_40/m1_n3706_n1374# 0.86518f
C899 NAND3_19/a_n593_982# VDD 2.7494f
C900 comp[50] NAND3_12/a_n593_982# 0.05055f
C901 NAND3_55/a_2506_982# comp[8] 0.30956f
C902 NAND3_0/m1_n2243_n1314# NAND3_0/m1_n3706_n1374# 0.9315f
C903 comp[39] comp[41] 0.15406f
C904 comp[22] NAND3_40/a_2506_982# 0.87927f
C905 NAND3_24/a_n593_982# wl[38] 0.05101f
C906 comp[23] NAND3_39/a_n593_982# 0.05055f
C907 NAND3_0/a_n593_982# NAND3_0/a_2506_982# 1.12155f
C908 comp[9] NAND3_54/m1_n2243_n1314# 0.20937f
C909 wl[60] VDD 2.04641f
C910 NAND3_53/a_2506_982# comp[8] 0.96225f
C911 NAND3_32/m1_n3706_n1374# NAND3_33/m1_n3706_n1374# 0.05965f
C912 NAND3_24/m1_n2243_n1314# comp[39] 0.20937f
C913 NAND3_14/m1_n2243_n1314# comp[49] 0.20937f
C914 comp[32] NAND3_30/m1_n2243_n1314# 0.16299f
C915 NAND3_47/m1_n3706_n1374# NAND3_46/m1_n3706_n1374# 0.05965f
C916 NAND3_62/a_2506_982# NAND3_62/a_n593_982# 1.12155f
C917 NAND3_51/a_n593_982# VDD 2.7494f
C918 NAND3_19/a_2506_982# NAND3_19/m1_n3706_n1374# 0.86518f
C919 comp[60] comp[59] 1.35332f
C920 NAND3_21/m1_n3706_n1374# comp[41] 0.32609f
C921 NAND3_30/a_2506_982# comp[31] 0.99086f
C922 NAND3_53/a_2506_982# NAND3_53/m1_n3706_n1374# 0.86518f
C923 NAND3_34/a_n593_982# comp[28] 0.05055f
C924 comp[50] NAND3_13/m1_n2243_n1314# 0.20948f
C925 comp[32] NAND3_29/a_2506_982# 0.96225f
C926 NAND3_16/a_2506_982# NAND3_16/m1_n3706_n1374# 0.86518f
C927 comp[60] NAND3_3/a_n593_982# 1.40214f
C928 comp[18] comp[19] 2.50926f
C929 comp[19] NAND3_44/a_2506_982# 0.31343f
C930 NAND3_29/m1_n2243_n1314# NAND3_29/m1_n3706_n1374# 0.9315f
C931 comp[45] comp[47] 0.15406f
C932 NAND3_25/a_2506_982# comp[36] 1.07676f
C933 NAND3_7/a_2506_982# NAND3_7/m1_n3706_n1374# 0.86518f
C934 NAND3_16/a_2506_982# wl[46] 1.10339f
C935 comp[60] NAND3_2/m1_n2243_n1314# 0.16299f
C936 comp[40] NAND3_22/a_2506_982# 0.87927f
C937 comp[9] NAND3_54/m1_n3706_n1374# 0.21268f
C938 comp[35] NAND3_28/m1_n2243_n1314# 0.20937f
C939 NAND3_37/a_n593_982# VDD 2.7494f
C940 NAND3_11/a_n593_982# wl[51] 0.05101f
C941 NAND3_35/a_2506_982# NAND3_35/a_n593_982# 1.12155f
C942 NAND3_17/a_2506_982# NAND3_17/a_n593_982# 1.12155f
C943 NAND3_45/a_n593_982# NAND3_45/m1_n2243_n1314# 0.33989f
C944 comp[39] VDD 3.15765f
C945 comp[17] NAND3_45/a_n593_982# 0.05055f
C946 NAND3_40/m1_n3706_n1374# NAND3_40/m1_n2243_n1314# 0.9315f
C947 NAND3_60/a_2506_982# NAND3_60/m1_n3706_n1374# 0.86518f
C948 NAND3_23/a_2506_982# NAND3_23/a_n593_982# 1.12155f
C949 comp[13] NAND3_48/a_2506_982# 0.99086f
C950 comp[48] VDD 3.15765f
C951 NAND3_6/a_n593_982# VDD 2.7494f
C952 wl[28] VDD 2.04641f
C953 NAND3_51/m1_n3706_n1374# NAND3_51/m1_n2243_n1314# 0.9315f
C954 comp[22] NAND3_40/m1_n2243_n1314# 0.16299f
C955 NAND3_17/a_2506_982# comp[44] 0.96225f
C956 comp[27] comp[25] 0.45884f
C957 wl[37] VDD 2.04642f
C958 wl[14] NAND3_48/a_2506_982# 1.10339f
C959 comp[7] NAND3_55/m1_n2243_n1314# 0.16299f
C960 comp[51] comp[52] 2.58001f
C961 NAND3_36/m1_n2243_n1314# NAND3_36/m1_n3706_n1374# 0.9315f
C962 wl[45] NAND3_17/a_n593_982# 0.05101f
C963 NAND3_15/a_n593_982# comp[48] 1.40214f
C964 comp[13] NAND3_50/a_n593_982# 1.40214f
C965 comp[55] NAND3_8/m1_n2243_n1314# 0.20937f
C966 comp[53] NAND3_10/a_n593_982# 1.40214f
C967 wl[51] NAND3_11/a_2506_982# 1.10339f
C968 comp[19] NAND3_43/a_2506_982# 0.83727f
C969 NAND3_62/a_2506_982# NAND3_62/m1_n3706_n1374# 0.86518f
C970 wl[57] VDD 2.04642f
C971 NAND3_59/a_2506_982# NAND3_59/m1_n3706_n1374# 0.86518f
C972 comp[46] NAND3_15/m1_n3706_n1374# 0.17282f
C973 NAND3_0/m1_n2243_n1314# NAND3_0/a_n593_982# 0.33989f
C974 NAND3_50/m1_n3706_n1374# NAND3_50/a_2506_982# 0.86518f
C975 NAND3_2/a_n593_982# NAND3_2/m1_n2243_n1314# 0.33989f
C976 NAND3_54/m1_n3706_n1374# comp[7] 0.19865f
C977 comp[46] NAND3_16/a_2506_982# 0.87927f
C978 NAND3_26/a_2506_982# VDD 6.45473f
C979 comp[38] comp[40] 0.10075f
C980 NAND3_6/a_n593_982# comp[56] 0.05055f
C981 NAND3_2/a_2506_982# comp[59] 0.95992f
C982 comp[13] NAND3_49/a_n593_982# 0.05055f
C983 NAND3_2/a_n593_982# wl[60] 0.05101f
C984 NAND3_53/a_n593_982# comp[10] 1.40214f
C985 NAND3_38/a_2506_982# wl[24] 1.10339f
C986 wl[25] NAND3_37/a_2506_982# 1.10339f
C987 NAND3_4/m1_n3706_n1374# comp[59] 0.21268f
C988 comp[41] VDD 2.90414f
C989 comp[38] NAND3_24/m1_n3706_n1374# 0.32579f
C990 comp[29] NAND3_33/m1_n3706_n1374# 0.32609f
C991 NAND3_32/a_2506_982# comp[30] 0.9579f
C992 NAND3_29/m1_n2243_n1314# comp[34] 0.20948f
C993 NAND3_30/m1_n3706_n1374# comp[32] 0.32579f
C994 comp[50] NAND3_11/a_2506_982# 0.96225f
C995 comp[24] NAND3_38/a_2506_982# 0.9579f
C996 NAND3_52/a_n593_982# VDD 2.7494f
C997 NAND3_14/m1_n2243_n1314# NAND3_14/a_n593_982# 0.33989f
C998 NAND3_16/m1_n2243_n1314# NAND3_17/m1_n2243_n1314# 0.05788f
C999 NAND3_26/m1_n2243_n1314# NAND3_26/m1_n3706_n1374# 0.9315f
C1000 comp[62] NAND3_0/a_2506_982# 0.80156f
C1001 wl[26] VDD 2.04641f
C1002 NAND3_2/m1_n3706_n1374# comp[59] 0.17481f
C1003 NAND3_57/m1_n2243_n1314# comp[5] 0.16299f
C1004 wl[8] VDD 2.04641f
C1005 NAND3_48/a_n593_982# comp[15] 1.40214f
C1006 wl[60] NAND3_2/a_2506_982# 1.10339f
C1007 comp[34] NAND3_28/m1_n2243_n1314# 0.16299f
C1008 comp[18] NAND3_44/a_n593_982# 0.05055f
C1009 NAND3_15/a_2506_982# wl[47] 1.10339f
C1010 NAND3_47/m1_n3706_n1374# comp[15] 0.37536f
C1011 NAND3_13/a_2506_982# NAND3_13/m1_n3706_n1374# 0.86518f
C1012 NAND3_44/a_n593_982# NAND3_44/a_2506_982# 1.12155f
C1013 NAND3_38/m1_n2243_n1314# NAND3_38/m1_n3706_n1374# 0.9315f
C1014 comp[61] VDD 2.9077f
C1015 comp[23] NAND3_39/m1_n3706_n1374# 0.32609f
C1016 comp[6] comp[7] 2.50926f
C1017 NAND3_9/a_2506_982# comp[52] 1.03779f
C1018 wl[58] NAND3_4/a_n593_982# 0.05101f
C1019 NAND3_47/a_2506_982# VDD 6.45473f
C1020 NAND3_49/a_n593_982# wl[13] 0.05101f
C1021 NAND3_49/a_2506_982# VDD 6.45473f
C1022 wl[4] NAND3_58/a_n593_982# 0.05101f
C1023 comp[51] NAND3_11/m1_n2243_n1314# 0.16299f
C1024 comp[9] NAND3_54/a_n593_982# 1.40214f
C1025 NAND3_28/a_n593_982# NAND3_28/m1_n2243_n1314# 0.33989f
C1026 NAND3_7/a_n593_982# comp[55] 0.05055f
C1027 NAND3_2/m1_n3706_n1374# NAND3_2/m1_n2243_n1314# 0.9315f
C1028 comp[62] NAND3_1/m1_n3706_n1374# 0.21467f
C1029 comp[31] NAND3_32/a_n593_982# 1.40214f
C1030 wl[16] NAND3_46/a_2506_982# 1.10339f
C1031 comp[11] comp[13] 0.44143f
C1032 comp[21] comp[19] 0.45884f
C1033 comp[21] NAND3_42/m1_n2243_n1314# 0.20937f
C1034 NAND3_40/a_n593_982# VDD 2.7494f
C1035 NAND3_28/a_2506_982# VDD 6.45473f
C1036 NAND3_15/a_n593_982# VDD 2.7494f
C1037 comp[44] NAND3_18/a_2506_982# 0.80389f
C1038 comp[35] NAND3_26/a_2506_982# 0.95992f
C1039 comp[36] NAND3_27/m1_n3706_n1374# 0.26395f
C1040 NAND3_51/a_2506_982# comp[12] 0.34787f
C1041 wl[20] VDD 2.04641f
C1042 wl[62] VDD 2.045f
C1043 NAND3_50/a_2506_982# VDD 6.45473f
C1044 comp[57] NAND3_6/a_2506_982# 0.42758f
C1045 comp[61] comp[60] 2.50926f
C1046 comp[56] VDD 2.90414f
C1047 wl[32] NAND3_30/a_n593_982# 0.05101f
C1048 comp[56] NAND3_6/m1_n3706_n1374# 0.32579f
C1049 NAND3_22/a_n593_982# comp[41] 1.40214f
C1050 NAND3_1/a_2506_982# NAND3_1/a_n593_982# 1.12155f
C1051 comp[39] comp[37] 0.45884f
C1052 wl[49] NAND3_13/a_2506_982# 1.10339f
C1053 comp[58] NAND3_5/a_2506_982# 0.30956f
C1054 wl[8] NAND3_54/a_2506_982# 1.10339f
C1055 wl[27] NAND3_35/a_n593_982# 0.05101f
C1056 NAND3_0/m1_n2243_n1314# comp[62] 0.16299f
C1057 NAND3_19/m1_n2243_n1314# comp[43] 0.16299f
C1058 comp[9] NAND3_53/m1_n2243_n1314# 0.16299f
C1059 NAND3_30/a_2506_982# VDD 6.45473f
C1060 NAND3_19/a_2506_982# comp[44] 0.30956f
C1061 comp[60] VDD 3.15765f
C1062 NAND3_57/a_2506_982# NAND3_57/m1_n3706_n1374# 0.86518f
C1063 comp[18] NAND3_44/m1_n3706_n1374# 0.37506f
C1064 comp[28] VDD 3.0571f
C1065 comp[61] NAND3_1/m1_n2243_n1314# 0.16299f
C1066 NAND3_6/m1_n2243_n1314# NAND3_7/m1_n2243_n1314# 0.05788f
C1067 wl[58] NAND3_4/a_2506_982# 1.10339f
C1068 NAND3_44/m1_n3706_n1374# NAND3_44/a_2506_982# 0.86518f
C1069 NAND3_56/a_2506_982# NAND3_56/m1_n3706_n1374# 0.86518f
C1070 NAND3_58/m1_n3706_n1374# comp[4] 0.32681f
C1071 wl[3] VDD 2.04642f
C1072 comp[45] comp[43] 0.45884f
C1073 wl[29] NAND3_33/a_n593_982# 0.05101f
C1074 NAND3_32/a_2506_982# NAND3_32/m1_n3706_n1374# 0.86518f
C1075 NAND3_57/m1_n3706_n1374# comp[5] 0.32609f
C1076 comp[15] comp[13] 0.45884f
C1077 NAND3_23/a_2506_982# wl[39] 1.10339f
C1078 NAND3_56/m1_n3706_n1374# comp[5] 0.17481f
C1079 NAND3_54/a_2506_982# VDD 6.45473f
C1080 comp[30] NAND3_31/m1_n3706_n1374# 0.17282f
C1081 comp[55] NAND3_6/a_2506_982# 0.99086f
C1082 NAND3_26/a_2506_982# comp[37] 0.31343f
C1083 comp[29] comp[27] 0.15406f
C1084 NAND3_17/m1_n3706_n1374# comp[45] 0.37536f
C1085 NAND3_23/m1_n3706_n1374# comp[39] 0.37536f
C1086 NAND3_2/a_n593_982# comp[61] 1.40214f
C1087 comp[42] comp[43] 2.50926f
C1088 NAND3_43/m1_n3706_n1374# comp[18] 0.17282f
C1089 NAND3_45/m1_n2243_n1314# comp[18] 0.20948f
C1090 NAND3_55/a_2506_982# wl[7] 1.10339f
C1091 comp[17] comp[18] 1.35332f
C1092 NAND3_5/a_2506_982# NAND3_5/m1_n3706_n1374# 0.86518f
C1093 NAND3_14/m1_n3706_n1374# comp[48] 0.37506f
C1094 NAND3_45/m1_n3706_n1374# comp[18] 0.26395f
C1095 comp[17] NAND3_44/a_2506_982# 0.95992f
C1096 wl[9] VDD 2.04641f
C1097 NAND3_53/a_2506_982# comp[9] 0.9579f
C1098 NAND3_51/a_2506_982# NAND3_51/a_n593_982# 1.12155f
C1099 comp[35] VDD 2.90414f
C1100 NAND3_22/a_n593_982# VDD 2.7494f
C1101 NAND3_2/a_n593_982# VDD 2.7494f
C1102 comp[6] NAND3_56/a_n593_982# 0.05055f
C1103 NAND3_39/a_n593_982# comp[24] 1.40214f
C1104 comp[35] NAND3_28/a_2506_982# 0.31189f
C1105 NAND3_4/m1_n2243_n1314# comp[58] 0.16299f
C1106 NAND3_4/a_2506_982# NAND3_4/a_n593_982# 1.12155f
C1107 comp[38] comp[36] 0.08982f
C1108 comp[13] NAND3_50/m1_n2243_n1314# 0.20937f
C1109 NAND3_10/a_2506_982# comp[52] 0.87927f
C1110 NAND3_10/m1_n2243_n1314# comp[52] 0.16299f
C1111 comp[21] comp[23] 0.15406f
C1112 wl[18] VDD 2.04641f
C1113 comp[20] comp[19] 2.57924f
C1114 NAND3_35/m1_n3706_n1374# comp[26] 0.17282f
C1115 comp[61] NAND3_2/a_2506_982# 0.31343f
C1116 comp[20] NAND3_42/m1_n2243_n1314# 0.16299f
C1117 NAND3_11/a_n593_982# comp[52] 1.40214f
C1118 NAND3_55/a_2506_982# comp[7] 0.83727f
C1119 comp[43] NAND3_20/m1_n3706_n1374# 0.21268f
C1120 NAND3_40/m1_n3706_n1374# comp[23] 0.21268f
C1121 comp[19] NAND3_44/m1_n2243_n1314# 0.20937f
C1122 NAND3_37/m1_n3706_n1374# comp[25] 0.34993f
C1123 NAND3_9/a_n593_982# comp[54] 1.40214f
C1124 comp[27] comp[26] 1.40927f
C1125 NAND3_42/a_n593_982# NAND3_42/m1_n2243_n1314# 0.33989f
C1126 NAND3_27/a_2506_982# VDD 6.45473f
C1127 wl[4] NAND3_58/a_2506_982# 1.10339f
C1128 NAND3_43/m1_n3706_n1374# NAND3_43/a_2506_982# 0.86518f
C1129 NAND3_43/a_n593_982# NAND3_43/m1_n2243_n1314# 0.33989f
C1130 comp[33] comp[32] 1.40927f
C1131 comp[22] comp[23] 2.51881f
C1132 NAND3_60/a_n593_982# NAND3_60/a_2506_982# 1.12155f
C1133 NAND3_2/a_2506_982# VDD 6.45473f
C1134 NAND3_43/a_n593_982# VDD 2.7494f
C1135 comp[55] comp[54] 2.50926f
C1136 comp[49] comp[47] 0.44143f
C1137 NAND3_30/m1_n3706_n1374# NAND3_30/m1_n2243_n1314# 0.9315f
C1138 NAND3_2/a_n593_982# comp[60] 0.05055f
C1139 comp[52] NAND3_11/a_2506_982# 0.30956f
C1140 wl[55] NAND3_7/a_2506_982# 1.10339f
C1141 comp[37] VDD 2.9108f
C1142 NAND3_5/a_n593_982# NAND3_5/a_2506_982# 1.12155f
C1143 NAND3_12/a_2506_982# comp[49] 0.99086f
C1144 comp[61] NAND3_2/m1_n3706_n1374# 0.21268f
C1145 NAND3_34/a_2506_982# NAND3_34/m1_n3706_n1374# 0.86518f
C1146 NAND3_19/a_2506_982# NAND3_19/a_n593_982# 1.12155f
C1147 comp[51] NAND3_12/m1_n2243_n1314# 0.20937f
C1148 comp[29] NAND3_32/a_2506_982# 0.95992f
C1149 comp[39] NAND3_22/m1_n3706_n1374# 0.22408f
C1150 comp[23] comp[25] 0.44143f
C1151 NAND3_4/a_2506_982# comp[57] 0.99962f
C1152 NAND3_14/a_2506_982# comp[47] 0.95992f
C1153 comp[11] NAND3_51/m1_n3706_n1374# 0.32609f
C1154 NAND3_27/m1_n3706_n1374# NAND3_26/m1_n3706_n1374# 0.05965f
C1155 comp[53] comp[51] 0.15406f
C1156 NAND3_2/a_2506_982# comp[60] 0.9579f
C1157 NAND3_31/a_2506_982# NAND3_31/m1_n3706_n1374# 0.86518f
C1158 wl[0] NAND3_62/a_n593_982# 0.05101f
C1159 comp[34] VDD 3.0571f
C1160 NAND3_41/a_2506_982# VDD 6.45473f
C1161 comp[3] NAND3_60/a_2506_982# 0.42758f
C1162 NAND3_26/a_2506_982# NAND3_26/a_n593_982# 1.12155f
C1163 comp[45] NAND3_18/m1_n3706_n1374# 0.21268f
C1164 wl[14] NAND3_48/a_n593_982# 0.05101f
C1165 NAND3_24/a_2506_982# NAND3_24/m1_n3706_n1374# 0.86518f
C1166 comp[13] NAND3_49/m1_n3706_n1374# 0.34993f
C1167 comp[42] NAND3_20/a_n593_982# 0.05055f
C1168 NAND3_8/a_2506_982# NAND3_8/m1_n3706_n1374# 0.86518f
C1169 NAND3_28/a_2506_982# comp[34] 0.87927f
C1170 NAND3_37/a_2506_982# NAND3_37/m1_n3706_n1374# 0.86518f
C1171 NAND3_10/m1_n2243_n1314# NAND3_11/m1_n2243_n1314# 0.05788f
C1172 NAND3_39/a_2506_982# VDD 6.45473f
C1173 comp[3] NAND3_59/a_2506_982# 0.9579f
C1174 NAND3_17/a_2506_982# VDD 6.45473f
C1175 NAND3_13/a_n593_982# VDD 2.7494f
C1176 wl[41] NAND3_21/a_2506_982# 1.10339f
C1177 NAND3_32/a_n593_982# VDD 2.7494f
C1178 comp[50] NAND3_12/a_2506_982# 0.80389f
C1179 NAND3_52/m1_n2243_n1314# NAND3_52/m1_n3706_n1374# 0.9315f
C1180 comp[16] comp[14] 0.10075f
C1181 NAND3_11/a_n593_982# NAND3_11/m1_n2243_n1314# 0.33989f
C1182 NAND3_10/a_n593_982# VDD 2.7494f
C1183 NAND3_31/m1_n2243_n1314# NAND3_31/m1_n3706_n1374# 0.9315f
C1184 NAND3_55/m1_n2243_n1314# NAND3_54/m1_n2243_n1314# 0.05788f
C1185 NAND3_19/m1_n2243_n1314# NAND3_19/m1_n3706_n1374# 0.9315f
C1186 NAND3_28/a_n593_982# VDD 2.7494f
C1187 NAND3_38/m1_n2243_n1314# NAND3_39/m1_n2243_n1314# 0.05788f
C1188 NAND3_16/a_n593_982# comp[47] 1.40214f
C1189 NAND3_37/a_n593_982# wl[25] 0.05101f
C1190 comp[10] NAND3_53/m1_n2243_n1314# 0.20948f
C1191 comp[32] NAND3_30/a_n593_982# 0.05055f
C1192 NAND3_28/a_n593_982# NAND3_28/a_2506_982# 1.12155f
C1193 NAND3_25/m1_n2243_n1314# NAND3_24/m1_n2243_n1314# 0.05788f
C1194 comp[35] NAND3_27/a_2506_982# 0.80459f
C1195 NAND3_14/a_2506_982# comp[49] 0.31343f
C1196 wl[45] VDD 2.04642f
C1197 comp[55] comp[57] 0.45884f
C1198 comp[32] comp[30] 0.08982f
C1199 NAND3_2/m1_n3706_n1374# comp[60] 0.37506f
C1200 comp[41] NAND3_22/m1_n3706_n1374# 0.21268f
C1201 comp[10] NAND3_51/m1_n3706_n1374# 0.17282f
C1202 comp[53] NAND3_8/a_2506_982# 0.95992f
C1203 NAND3_54/m1_n3706_n1374# NAND3_54/m1_n2243_n1314# 0.9315f
C1204 NAND3_2/a_n593_982# NAND3_2/a_2506_982# 1.12155f
C1205 comp[45] NAND3_16/m1_n3706_n1374# 0.22408f
C1206 comp[42] NAND3_19/m1_n3706_n1374# 0.17282f
C1207 NAND3_15/m1_n3706_n1374# comp[48] 0.26395f
C1208 comp[50] comp[49] 2.57924f
C1209 NAND3_56/a_2506_982# comp[7] 0.31343f
C1210 NAND3_44/a_n593_982# NAND3_44/m1_n2243_n1314# 0.33989f
C1211 comp[35] comp[37] 0.44143f
C1212 NAND3_36/a_n593_982# comp[26] 0.05055f
C1213 comp[29] NAND3_34/m1_n2243_n1314# 0.20937f
C1214 comp[15] NAND3_47/m1_n2243_n1314# 0.16299f
C1215 comp[24] NAND3_39/m1_n3706_n1374# 0.26395f
C1216 NAND3_25/m1_n3706_n1374# comp[37] 0.34993f
C1217 comp[7] comp[5] 0.44143f
C1218 NAND3_51/a_2506_982# VDD 6.45473f
C1219 comp[31] NAND3_32/a_2506_982# 0.31343f
C1220 NAND3_56/a_2506_982# wl[6] 1.10339f
C1221 NAND3_53/a_2506_982# comp[10] 0.30956f
C1222 comp[12] NAND3_51/m1_n2243_n1314# 0.20948f
C1223 comp[53] NAND3_9/a_2506_982# 0.80459f
C1224 NAND3_26/a_n593_982# VDD 2.7494f
C1225 wl[61] VDD 2.04642f
C1226 NAND3_9/a_2506_982# NAND3_9/m1_n3706_n1374# 0.86518f
C1227 NAND3_8/a_n593_982# NAND3_8/a_2506_982# 1.12155f
C1228 comp[2] comp[4] 0.10075f
C1229 wl[16] VDD 2.04641f
C1230 comp[61] NAND3_0/a_2506_982# 0.99192f
C1231 comp[35] comp[34] 2.51881f
C1232 NAND3_45/a_n593_982# comp[18] 1.40214f
C1233 NAND3_12/a_n593_982# NAND3_12/m1_n2243_n1314# 0.33989f
C1234 NAND3_32/m1_n2243_n1314# comp[30] 0.16299f
C1235 NAND3_48/m1_n2243_n1314# NAND3_48/m1_n3706_n1374# 0.9315f
C1236 NAND3_52/a_2506_982# NAND3_52/m1_n3706_n1374# 0.86518f
C1237 NAND3_29/m1_n3706_n1374# comp[34] 0.2157f
C1238 comp[28] NAND3_33/m1_n3706_n1374# 0.17282f
C1239 comp[2] NAND3_61/a_n593_982# 1.40214f
C1240 comp[30] NAND3_33/m1_n2243_n1314# 0.20948f
C1241 wl[52] VDD 2.04642f
C1242 NAND3_24/a_2506_982# wl[38] 1.10339f
C1243 wl[50] VDD 2.04641f
C1244 NAND3_36/m1_n2243_n1314# comp[27] 0.20937f
C1245 NAND3_0/a_2506_982# VDD 6.44729f
C1246 comp[46] comp[45] 2.58001f
C1247 NAND3_28/a_n593_982# comp[35] 1.40214f
C1248 NAND3_14/a_n593_982# comp[49] 1.40214f
C1249 NAND3_23/m1_n2243_n1314# comp[39] 0.16299f
C1250 comp[51] NAND3_10/m1_n3706_n1374# 0.22408f
C1251 NAND3_46/m1_n3706_n1374# NAND3_46/m1_n2243_n1314# 0.9315f
C1252 comp[9] NAND3_52/a_2506_982# 0.99962f
C1253 NAND3_12/m1_n2243_n1314# NAND3_13/m1_n2243_n1314# 0.05788f
C1254 comp[34] NAND3_27/a_2506_982# 1.03779f
C1255 comp[38] NAND3_25/a_2506_982# 0.30956f
C1256 NAND3_2/m1_n3706_n1374# NAND3_2/a_2506_982# 0.86518f
C1257 NAND3_18/a_2506_982# VDD 6.45473f
C1258 NAND3_58/m1_n3706_n1374# NAND3_59/m1_n3706_n1374# 0.05965f
C1259 comp[58] NAND3_3/m1_n3706_n1374# 0.17282f
C1260 comp[61] NAND3_1/m1_n3706_n1374# 0.34993f
C1261 NAND3_44/m1_n3706_n1374# NAND3_44/m1_n2243_n1314# 0.9315f
C1262 wl[19] VDD 2.04642f
C1263 NAND3_3/m1_n2243_n1314# NAND3_3/m1_n3706_n1374# 0.9315f
C1264 wl[40] VDD 2.04641f
C1265 wl[62] NAND3_0/a_2506_982# 1.10339f
C1266 comp[16] NAND3_46/m1_n3706_n1374# 0.32681f
C1267 NAND3_29/a_n593_982# NAND3_29/a_2506_982# 1.12155f
C1268 wl[56] NAND3_6/a_n593_982# 0.05101f
C1269 comp[47] NAND3_15/a_2506_982# 0.80459f
C1270 wl[4] VDD 2.04641f
C1271 NAND3_6/m1_n2243_n1314# NAND3_6/a_n593_982# 0.33989f
C1272 NAND3_4/m1_n2243_n1314# comp[59] 0.20937f
C1273 comp[33] NAND3_30/m1_n2243_n1314# 0.20937f
C1274 NAND3_43/m1_n3706_n1374# comp[20] 0.21467f
C1275 comp[38] NAND3_24/a_n593_982# 0.05055f
C1276 NAND3_34/a_n593_982# NAND3_34/m1_n2243_n1314# 0.33989f
C1277 NAND3_53/a_n593_982# NAND3_53/m1_n2243_n1314# 0.33989f
C1278 NAND3_58/m1_n3706_n1374# comp[5] 0.21268f
C1279 NAND3_14/a_2506_982# NAND3_14/a_n593_982# 1.12155f
C1280 NAND3_40/a_2506_982# VDD 6.45473f
C1281 wl[25] VDD 2.04641f
C1282 NAND3_36/m1_n3706_n1374# comp[27] 0.21268f
C1283 NAND3_51/a_n593_982# NAND3_51/m1_n2243_n1314# 0.33989f
C1284 wl[44] VDD 2.04641f
C1285 comp[32] NAND3_31/a_2506_982# 0.30956f
C1286 NAND3_40/a_2506_982# NAND3_40/a_n593_982# 1.12155f
C1287 comp[2] comp[1] 2.57924f
C1288 comp[62] NAND3_1/a_n593_982# 1.40214f
C1289 comp[21] NAND3_42/a_2506_982# 0.42758f
C1290 NAND3_45/m1_n2243_n1314# NAND3_44/m1_n2243_n1314# 0.05788f
C1291 comp[54] comp[52] 0.1031f
C1292 comp[33] NAND3_29/a_2506_982# 0.9579f
C1293 comp[51] NAND3_11/m1_n3706_n1374# 0.37536f
C1294 NAND3_54/a_n593_982# NAND3_54/m1_n2243_n1314# 0.33989f
C1295 comp[11] NAND3_52/m1_n2243_n1314# 0.20937f
C1296 NAND3_19/a_2506_982# VDD 6.45473f
C1297 comp[26] NAND3_37/m1_n3706_n1374# 0.21467f
C1298 NAND3_16/a_2506_982# VDD 6.45473f
C1299 NAND3_56/a_2506_982# NAND3_56/a_n593_982# 1.12155f
C1300 comp[12] comp[14] 0.08982f
C1301 comp[42] NAND3_21/a_n593_982# 1.40214f
C1302 wl[34] VDD 2.04642f
C1303 NAND3_8/m1_n2243_n1314# NAND3_8/m1_n3706_n1374# 0.9315f
C1304 NAND3_7/a_2506_982# VDD 6.45473f
C1305 NAND3_58/m1_n3706_n1374# NAND3_58/m1_n2243_n1314# 0.9315f
C1306 comp[17] NAND3_46/m1_n2243_n1314# 0.20937f
C1307 NAND3_36/a_2506_982# comp[25] 0.99086f
C1308 NAND3_31/m1_n2243_n1314# comp[32] 0.20948f
C1309 NAND3_61/m1_n3706_n1374# comp[2] 0.21467f
C1310 comp[27] VDD 3.15765f
C1311 NAND3_28/a_2506_982# wl[34] 1.10339f
C1312 NAND3_25/m1_n2243_n1314# NAND3_25/m1_n3706_n1374# 0.9315f
C1313 NAND3_47/m1_n3706_n1374# NAND3_47/m1_n2243_n1314# 0.9315f
C1314 NAND3_60/a_2506_982# VDD 6.45473f
C1315 NAND3_14/a_2506_982# wl[48] 1.10339f
C1316 NAND3_13/m1_n3706_n1374# comp[48] 0.17282f
C1317 NAND3_21/a_n593_982# NAND3_21/a_2506_982# 1.12155f
C1318 NAND3_53/a_2506_982# NAND3_53/a_n593_982# 1.12155f
C1319 comp[16] comp[17] 2.51881f
C1320 comp[16] NAND3_45/m1_n3706_n1374# 0.17282f
C1321 comp[2] m1_n4168_2156# 0.08982f
C1322 wl[57] NAND3_5/a_2506_982# 1.10339f
C1323 comp[33] NAND3_28/m1_n3706_n1374# 0.22408f
C1324 comp[31] NAND3_31/m1_n3706_n1374# 0.34993f
C1325 NAND3_59/a_2506_982# VDD 6.45473f
C1326 comp[53] NAND3_10/a_2506_982# 0.31189f
C1327 NAND3_62/a_2506_982# VDD 7.41465f
C1328 NAND3_1/m1_n3706_n1374# comp[60] 0.17282f
C1329 NAND3_10/m1_n2243_n1314# comp[53] 0.20937f
C1330 comp[6] comp[4] 0.1031f
C1331 comp[56] NAND3_7/a_2506_982# 0.30956f
C1332 wl[36] NAND3_26/a_2506_982# 1.10339f
C1333 NAND3_28/a_n593_982# comp[34] 0.05055f
C1334 NAND3_55/a_n593_982# VDD 2.7494f
C1335 NAND3_52/m1_n2243_n1314# comp[10] 0.16299f
C1336 NAND3_23/a_2506_982# comp[38] 0.96225f
C1337 comp[22] comp[24] 0.1031f
C1338 NAND3_32/m1_n3706_n1374# NAND3_32/m1_n2243_n1314# 0.9315f
C1339 NAND3_35/m1_n3706_n1374# comp[28] 0.2157f
C1340 NAND3_7/a_n593_982# NAND3_7/m1_n2243_n1314# 0.33989f
C1341 NAND3_33/a_n593_982# NAND3_33/m1_n2243_n1314# 0.33989f
C1342 comp[8] VDD 2.90414f
C1343 NAND3_1/m1_n2243_n1314# NAND3_1/m1_n3706_n1374# 0.9315f
C1344 NAND3_4/m1_n2243_n1314# NAND3_5/m1_n2243_n1314# 0.05788f
C1345 comp[25] NAND3_38/a_2506_982# 0.31343f
C1346 NAND3_40/m1_n2243_n1314# NAND3_40/a_n593_982# 0.33989f
C1347 comp[14] NAND3_48/m1_n3706_n1374# 0.32579f
C1348 NAND3_36/m1_n2243_n1314# NAND3_36/a_n593_982# 0.33989f
C1349 wl[40] NAND3_22/a_n593_982# 0.05101f
C1350 NAND3_25/m1_n2243_n1314# comp[37] 0.16299f
C1351 NAND3_30/m1_n2243_n1314# NAND3_30/a_n593_982# 0.33989f
C1352 NAND3_19/m1_n2243_n1314# comp[44] 0.20948f
C1353 NAND3_27/m1_n2243_n1314# comp[36] 0.20948f
C1354 NAND3_26/a_n593_982# comp[37] 1.40214f
C1355 comp[27] comp[28] 2.58001f
C1356 NAND3_17/a_n593_982# comp[45] 0.05055f
C1357 NAND3_17/a_2506_982# wl[45] 1.10339f
C1358 NAND3_25/a_n593_982# NAND3_25/a_2506_982# 1.12155f
C1359 comp[11] NAND3_52/a_2506_982# 0.31189f
C1360 NAND3_61/a_2506_982# VDD 6.45473f
C1361 comp[54] NAND3_7/m1_n3706_n1374# 0.17282f
C1362 wl[56] VDD 2.04641f
C1363 comp[45] comp[44] 1.40927f
C1364 NAND3_6/m1_n2243_n1314# NAND3_6/m1_n3706_n1374# 0.9315f
C1365 NAND3_30/m1_n3706_n1374# comp[33] 0.21268f
C1366 NAND3_21/m1_n2243_n1314# comp[42] 0.20948f
C1367 NAND3_46/a_2506_982# NAND3_46/m1_n3706_n1374# 0.86518f
C1368 NAND3_45/a_n593_982# wl[17] 0.05101f
C1369 NAND3_8/a_n593_982# NAND3_8/m1_n2243_n1314# 0.33989f
C1370 NAND3_59/a_2506_982# wl[3] 1.10339f
C1371 wl[26] NAND3_36/a_n593_982# 0.05101f
C1372 comp[42] comp[44] 0.08982f
C1373 comp[24] comp[25] 2.50926f
C1374 comp[20] NAND3_42/a_2506_982# 0.80389f
C1375 comp[12] NAND3_50/a_n593_982# 0.05055f
C1376 wl[19] NAND3_43/a_n593_982# 0.05101f
C1377 NAND3_0/m1_n2243_n1314# NAND3_1/m1_n2243_n1314# 0.05788f
C1378 comp[39] comp[40] 2.58001f
C1379 comp[16] comp[15] 2.58001f
C1380 NAND3_14/a_n593_982# wl[48] 0.05101f
C1381 NAND3_31/a_n593_982# NAND3_31/a_2506_982# 1.12155f
C1382 NAND3_35/m1_n2243_n1314# comp[28] 0.20948f
C1383 NAND3_32/a_2506_982# VDD 6.45473f
C1384 NAND3_42/a_n593_982# NAND3_42/a_2506_982# 1.12155f
C1385 NAND3_6/m1_n2243_n1314# comp[56] 0.16299f
C1386 wl[29] VDD 2.04642f
C1387 wl[1] NAND3_61/a_n593_982# 0.05101f
C1388 wl[27] NAND3_35/a_2506_982# 1.10339f
C1389 NAND3_59/m1_n2243_n1314# comp[4] 0.20948f
C1390 comp[47] NAND3_16/m1_n3706_n1374# 0.21268f
C1391 NAND3_61/a_n593_982# comp[1] 0.05055f
C1392 wl[36] VDD 2.04642f
C1393 NAND3_5/a_2506_982# VDD 6.45473f
C1394 comp[39] NAND3_24/m1_n3706_n1374# 0.21268f
C1395 comp[40] NAND3_21/m1_n3706_n1374# 0.17282f
C1396 NAND3_54/a_2506_982# comp[8] 0.80389f
C1397 NAND3_23/m1_n3706_n1374# NAND3_22/m1_n3706_n1374# 0.05965f
C1398 NAND3_57/a_n593_982# wl[5] 0.05101f
C1399 NAND3_46/a_n593_982# NAND3_46/m1_n2243_n1314# 0.33989f
C1400 comp[10] NAND3_52/a_2506_982# 0.87927f
C1401 comp[18] NAND3_44/a_2506_982# 0.9579f
C1402 comp[51] VDD 3.15765f
C1403 NAND3_31/m1_n2243_n1314# NAND3_31/a_n593_982# 0.33989f
C1404 NAND3_36/a_n593_982# VDD 2.7494f
C1405 comp[50] comp[52] 0.10075f
C1406 comp[17] NAND3_46/a_2506_982# 0.31189f
C1407 NAND3_48/a_2506_982# NAND3_48/m1_n3706_n1374# 0.86518f
C1408 comp[16] NAND3_46/a_n593_982# 0.05055f
C1409 NAND3_10/a_n593_982# wl[52] 0.05101f
C1410 NAND3_5/a_2506_982# comp[56] 0.96225f
C1411 comp[58] NAND3_4/a_n593_982# 0.05055f
C1412 NAND3_59/a_n593_982# comp[4] 1.40214f
C1413 NAND3_10/a_2506_982# NAND3_10/m1_n3706_n1374# 0.86518f
C1414 comp[40] comp[41] 2.51881f
C1415 NAND3_10/m1_n2243_n1314# NAND3_10/m1_n3706_n1374# 0.9315f
C1416 NAND3_13/a_2506_982# comp[49] 0.83727f
C1417 NAND3_57/a_n593_982# comp[6] 1.40214f
C1418 comp[29] NAND3_33/m1_n2243_n1314# 0.16299f
C1419 comp[2] NAND3_60/m1_n3706_n1374# 0.32579f
C1420 comp[24] NAND3_37/a_2506_982# 1.07676f
C1421 NAND3_3/a_2506_982# NAND3_3/m1_n3706_n1374# 0.86518f
C1422 NAND3_31/a_n593_982# wl[31] 0.05101f
C1423 NAND3_8/a_2506_982# VDD 6.45473f
C1424 NAND3_38/a_n593_982# NAND3_38/a_2506_982# 1.12155f
C1425 comp[2] NAND3_59/m1_n3706_n1374# 0.17282f
C1426 wl[21] NAND3_41/a_n593_982# 0.05101f
C1427 comp[6] NAND3_55/a_2506_982# 1.07676f
C1428 NAND3_43/m1_n2243_n1314# comp[19] 0.16299f
C1429 comp[18] NAND3_43/a_2506_982# 1.07676f
C1430 NAND3_27/m1_n2243_n1314# NAND3_27/a_n593_982# 0.33989f
C1431 NAND3_43/m1_n2243_n1314# NAND3_42/m1_n2243_n1314# 0.05788f
C1432 NAND3_14/m1_n3706_n1374# NAND3_15/m1_n3706_n1374# 0.05965f
C1433 NAND3_19/m1_n2243_n1314# NAND3_19/a_n593_982# 0.33989f
C1434 comp[46] comp[47] 2.51881f
C1435 wl[49] VDD 2.04642f
C1436 comp[32] comp[31] 2.57924f
C1437 wl[35] VDD 2.04642f
C1438 comp[19] VDD 2.9108f
C1439 NAND3_24/m1_n2243_n1314# NAND3_24/m1_n3706_n1374# 0.9315f
C1440 comp[44] GND 8.50855f
C1441 NAND3_19/a_n593_982# GND 3.4878f **FLOATING
C1442 wl[43] GND 2.74229f
C1443 NAND3_19/m1_n3706_n1374# GND 1.84123f **FLOATING
C1444 NAND3_19/a_2506_982# GND 3.7281f **FLOATING
C1445 NAND3_19/m1_n2243_n1314# GND 2.54113f **FLOATING
C1446 comp[54] GND 7.50376f
C1447 NAND3_9/a_n593_982# GND 3.4878f **FLOATING
C1448 wl[53] GND 2.74228f
C1449 NAND3_9/m1_n3706_n1374# GND 1.84123f **FLOATING
C1450 NAND3_9/a_2506_982# GND 3.7281f **FLOATING
C1451 NAND3_9/m1_n2243_n1314# GND 2.54113f **FLOATING
C1452 comp[34] GND 7.78651f
C1453 NAND3_29/a_n593_982# GND 3.4878f **FLOATING
C1454 wl[33] GND 2.74228f
C1455 NAND3_29/m1_n3706_n1374# GND 1.84123f **FLOATING
C1456 NAND3_29/a_2506_982# GND 3.7281f **FLOATING
C1457 NAND3_29/m1_n2243_n1314# GND 2.54113f **FLOATING
C1458 comp[45] GND 7.77545f
C1459 NAND3_18/a_n593_982# GND 3.4878f **FLOATING
C1460 wl[44] GND 2.74229f
C1461 NAND3_18/m1_n3706_n1374# GND 1.84123f **FLOATING
C1462 NAND3_18/a_2506_982# GND 3.7281f **FLOATING
C1463 NAND3_18/m1_n2243_n1314# GND 2.54113f **FLOATING
C1464 comp[55] GND 8.16541f
C1465 NAND3_8/a_n593_982# GND 3.4878f **FLOATING
C1466 wl[54] GND 2.74229f
C1467 NAND3_8/m1_n3706_n1374# GND 1.84123f **FLOATING
C1468 NAND3_8/a_2506_982# GND 3.7281f **FLOATING
C1469 NAND3_8/m1_n2243_n1314# GND 2.54113f **FLOATING
C1470 comp[24] GND 7.50376f
C1471 NAND3_39/a_n593_982# GND 3.4878f **FLOATING
C1472 wl[23] GND 2.74228f
C1473 NAND3_39/m1_n3706_n1374# GND 1.84123f **FLOATING
C1474 NAND3_39/a_2506_982# GND 3.7281f **FLOATING
C1475 NAND3_39/m1_n2243_n1314# GND 2.54113f **FLOATING
C1476 comp[35] GND 8.83671f
C1477 NAND3_28/a_n593_982# GND 3.4878f **FLOATING
C1478 wl[34] GND 2.74228f
C1479 NAND3_28/m1_n3706_n1374# GND 1.84123f **FLOATING
C1480 NAND3_28/a_2506_982# GND 3.7281f **FLOATING
C1481 NAND3_28/m1_n2243_n1314# GND 2.54113f **FLOATING
C1482 comp[46] GND 7.78651f
C1483 NAND3_17/a_n593_982# GND 3.4878f **FLOATING
C1484 wl[45] GND 2.74228f
C1485 NAND3_17/m1_n3706_n1374# GND 1.84123f **FLOATING
C1486 NAND3_17/a_2506_982# GND 3.7281f **FLOATING
C1487 NAND3_17/m1_n2243_n1314# GND 2.54113f **FLOATING
C1488 comp[56] GND 8.50855f
C1489 NAND3_7/a_n593_982# GND 3.4878f **FLOATING
C1490 wl[55] GND 2.74228f
C1491 NAND3_7/m1_n3706_n1374# GND 1.84123f **FLOATING
C1492 NAND3_7/a_2506_982# GND 3.7281f **FLOATING
C1493 NAND3_7/m1_n2243_n1314# GND 2.54113f **FLOATING
C1494 comp[14] GND 8.50855f
C1495 NAND3_49/a_n593_982# GND 3.4878f **FLOATING
C1496 wl[13] GND 2.74229f
C1497 NAND3_49/m1_n3706_n1374# GND 1.84123f **FLOATING
C1498 NAND3_49/a_2506_982# GND 3.7281f **FLOATING
C1499 NAND3_49/m1_n2243_n1314# GND 2.54113f **FLOATING
C1500 comp[25] GND 8.16541f
C1501 NAND3_38/a_n593_982# GND 3.4878f **FLOATING
C1502 wl[24] GND 2.74229f
C1503 NAND3_38/m1_n3706_n1374# GND 1.84123f **FLOATING
C1504 NAND3_38/a_2506_982# GND 3.7281f **FLOATING
C1505 NAND3_38/m1_n2243_n1314# GND 2.54113f **FLOATING
C1506 comp[36] GND 7.50376f
C1507 NAND3_27/a_n593_982# GND 3.4878f **FLOATING
C1508 wl[35] GND 2.74228f
C1509 NAND3_27/m1_n3706_n1374# GND 1.84123f **FLOATING
C1510 NAND3_27/a_2506_982# GND 3.7281f **FLOATING
C1511 NAND3_27/m1_n2243_n1314# GND 2.54113f **FLOATING
C1512 comp[47] GND 8.83671f
C1513 NAND3_16/a_n593_982# GND 3.4878f **FLOATING
C1514 wl[46] GND 2.74229f
C1515 NAND3_16/m1_n3706_n1374# GND 1.84123f **FLOATING
C1516 NAND3_16/a_2506_982# GND 3.7281f **FLOATING
C1517 NAND3_16/m1_n2243_n1314# GND 2.54113f **FLOATING
C1518 comp[57] GND 7.77545f
C1519 NAND3_6/a_n593_982# GND 3.4878f **FLOATING
C1520 wl[56] GND 2.74229f
C1521 NAND3_6/m1_n3706_n1374# GND 1.84123f **FLOATING
C1522 NAND3_6/a_2506_982# GND 3.7281f **FLOATING
C1523 NAND3_6/m1_n2243_n1314# GND 2.54113f **FLOATING
C1524 comp[58] GND 7.7865f
C1525 NAND3_5/a_n593_982# GND 3.4878f **FLOATING
C1526 wl[57] GND 2.74228f
C1527 NAND3_5/m1_n3706_n1374# GND 1.84123f **FLOATING
C1528 NAND3_5/a_2506_982# GND 3.7281f **FLOATING
C1529 NAND3_5/m1_n2243_n1314# GND 2.54113f **FLOATING
C1530 comp[4] GND 7.78651f
C1531 NAND3_59/a_n593_982# GND 3.4878f **FLOATING
C1532 wl[3] GND 2.74228f
C1533 NAND3_59/m1_n3706_n1374# GND 1.84123f **FLOATING
C1534 NAND3_59/a_2506_982# GND 3.7281f **FLOATING
C1535 NAND3_59/m1_n2243_n1314# GND 2.54113f **FLOATING
C1536 comp[15] GND 7.77545f
C1537 NAND3_48/a_n593_982# GND 3.4878f **FLOATING
C1538 wl[14] GND 2.74229f
C1539 NAND3_48/m1_n3706_n1374# GND 1.84123f **FLOATING
C1540 NAND3_48/a_2506_982# GND 3.7281f **FLOATING
C1541 NAND3_48/m1_n2243_n1314# GND 2.54113f **FLOATING
C1542 comp[26] GND 8.50855f
C1543 NAND3_37/a_n593_982# GND 3.4878f **FLOATING
C1544 wl[25] GND 2.74229f
C1545 NAND3_37/m1_n3706_n1374# GND 1.84123f **FLOATING
C1546 NAND3_37/a_2506_982# GND 3.7281f **FLOATING
C1547 NAND3_37/m1_n2243_n1314# GND 2.54113f **FLOATING
C1548 comp[37] GND 8.16774f
C1549 NAND3_26/a_n593_982# GND 3.4878f **FLOATING
C1550 wl[36] GND 2.74228f
C1551 NAND3_26/m1_n3706_n1374# GND 1.84123f **FLOATING
C1552 NAND3_26/a_2506_982# GND 3.7281f **FLOATING
C1553 NAND3_26/m1_n2243_n1314# GND 2.54113f **FLOATING
C1554 comp[48] GND 7.50376f
C1555 NAND3_15/a_n593_982# GND 3.4878f **FLOATING
C1556 wl[47] GND 2.74228f
C1557 NAND3_15/m1_n3706_n1374# GND 1.84123f **FLOATING
C1558 NAND3_15/a_2506_982# GND 3.7281f **FLOATING
C1559 NAND3_15/m1_n2243_n1314# GND 2.54113f **FLOATING
C1560 comp[59] GND 8.83671f
C1561 NAND3_4/a_n593_982# GND 3.4878f **FLOATING
C1562 wl[58] GND 2.74229f
C1563 NAND3_4/m1_n3706_n1374# GND 1.84123f **FLOATING
C1564 NAND3_4/a_2506_982# GND 3.7281f **FLOATING
C1565 NAND3_4/m1_n2243_n1314# GND 2.54113f **FLOATING
C1566 comp[5] GND 8.83671f
C1567 NAND3_58/a_n593_982# GND 3.4878f **FLOATING
C1568 wl[4] GND 2.74229f
C1569 NAND3_58/m1_n3706_n1374# GND 1.84123f **FLOATING
C1570 NAND3_58/a_2506_982# GND 3.7281f **FLOATING
C1571 NAND3_58/m1_n2243_n1314# GND 2.54113f **FLOATING
C1572 comp[6] GND 7.50376f
C1573 NAND3_57/a_n593_982# GND 3.4878f **FLOATING
C1574 wl[5] GND 2.74228f
C1575 NAND3_57/m1_n3706_n1374# GND 1.84123f **FLOATING
C1576 NAND3_57/a_2506_982# GND 3.7281f **FLOATING
C1577 NAND3_57/m1_n2243_n1314# GND 2.54113f **FLOATING
C1578 comp[16] GND 7.78651f
C1579 NAND3_47/a_n593_982# GND 3.4878f **FLOATING
C1580 wl[15] GND 2.74228f
C1581 NAND3_47/m1_n3706_n1374# GND 1.84123f **FLOATING
C1582 NAND3_47/a_2506_982# GND 3.7281f **FLOATING
C1583 NAND3_47/m1_n2243_n1314# GND 2.54113f **FLOATING
C1584 comp[17] GND 8.83671f
C1585 NAND3_46/a_n593_982# GND 3.4878f **FLOATING
C1586 wl[16] GND 2.74229f
C1587 NAND3_46/m1_n3706_n1374# GND 1.84123f **FLOATING
C1588 NAND3_46/a_2506_982# GND 3.7281f **FLOATING
C1589 NAND3_46/m1_n2243_n1314# GND 2.54113f **FLOATING
C1590 comp[27] GND 7.77545f
C1591 NAND3_36/a_n593_982# GND 3.4878f **FLOATING
C1592 wl[26] GND 2.74229f
C1593 NAND3_36/m1_n3706_n1374# GND 1.84123f **FLOATING
C1594 NAND3_36/a_2506_982# GND 3.7281f **FLOATING
C1595 NAND3_36/m1_n2243_n1314# GND 2.54113f **FLOATING
C1596 comp[28] GND 7.78651f
C1597 NAND3_35/a_n593_982# GND 3.4878f **FLOATING
C1598 wl[27] GND 2.74229f
C1599 NAND3_35/m1_n3706_n1374# GND 1.84123f **FLOATING
C1600 NAND3_35/a_2506_982# GND 3.7281f **FLOATING
C1601 NAND3_35/m1_n2243_n1314# GND 2.54113f **FLOATING
C1602 comp[38] GND 8.51087f
C1603 NAND3_25/a_n593_982# GND 3.4878f **FLOATING
C1604 wl[37] GND 2.74228f
C1605 NAND3_25/m1_n3706_n1374# GND 1.84123f **FLOATING
C1606 NAND3_25/a_2506_982# GND 3.7281f **FLOATING
C1607 NAND3_25/m1_n2243_n1314# GND 2.54113f **FLOATING
C1608 comp[39] GND 7.77545f
C1609 NAND3_24/a_n593_982# GND 3.4878f **FLOATING
C1610 wl[38] GND 2.74229f
C1611 NAND3_24/m1_n3706_n1374# GND 1.84123f **FLOATING
C1612 NAND3_24/a_2506_982# GND 3.7281f **FLOATING
C1613 NAND3_24/m1_n2243_n1314# GND 2.54113f **FLOATING
C1614 comp[49] GND 8.16541f
C1615 NAND3_14/a_n593_982# GND 3.4878f **FLOATING
C1616 wl[48] GND 2.74229f
C1617 NAND3_14/m1_n3706_n1374# GND 1.84123f **FLOATING
C1618 NAND3_14/a_2506_982# GND 3.7281f **FLOATING
C1619 NAND3_14/m1_n2243_n1314# GND 2.54113f **FLOATING
C1620 comp[50] GND 8.50855f
C1621 NAND3_13/a_n593_982# GND 3.4878f **FLOATING
C1622 wl[49] GND 2.74228f
C1623 NAND3_13/m1_n3706_n1374# GND 1.84123f **FLOATING
C1624 NAND3_13/a_2506_982# GND 3.7281f **FLOATING
C1625 NAND3_13/m1_n2243_n1314# GND 2.54113f **FLOATING
C1626 comp[60] GND 7.50376f
C1627 NAND3_3/a_n593_982# GND 3.4878f **FLOATING
C1628 wl[59] GND 2.74229f
C1629 NAND3_3/m1_n3706_n1374# GND 1.84123f **FLOATING
C1630 NAND3_3/a_2506_982# GND 3.7281f **FLOATING
C1631 NAND3_3/m1_n2243_n1314# GND 2.54113f **FLOATING
C1632 comp[7] GND 8.16541f
C1633 NAND3_56/a_n593_982# GND 3.4878f **FLOATING
C1634 wl[6] GND 2.74229f
C1635 NAND3_56/m1_n3706_n1374# GND 1.84123f **FLOATING
C1636 NAND3_56/a_2506_982# GND 3.7281f **FLOATING
C1637 NAND3_56/m1_n2243_n1314# GND 2.54113f **FLOATING
C1638 comp[18] GND 7.50376f
C1639 NAND3_45/a_n593_982# GND 3.4878f **FLOATING
C1640 wl[17] GND 2.74228f
C1641 NAND3_45/m1_n3706_n1374# GND 1.84123f **FLOATING
C1642 NAND3_45/a_2506_982# GND 3.7281f **FLOATING
C1643 NAND3_45/m1_n2243_n1314# GND 2.54113f **FLOATING
C1644 comp[29] GND 8.83671f
C1645 NAND3_34/a_n593_982# GND 3.4878f **FLOATING
C1646 wl[28] GND 2.74229f
C1647 NAND3_34/m1_n3706_n1374# GND 1.84123f **FLOATING
C1648 NAND3_34/a_2506_982# GND 3.7281f **FLOATING
C1649 NAND3_34/m1_n2243_n1314# GND 2.54113f **FLOATING
C1650 comp[40] GND 7.78651f
C1651 NAND3_23/a_n593_982# GND 3.4878f **FLOATING
C1652 wl[39] GND 2.74228f
C1653 NAND3_23/m1_n3706_n1374# GND 1.84123f **FLOATING
C1654 NAND3_23/a_2506_982# GND 3.7281f **FLOATING
C1655 NAND3_23/m1_n2243_n1314# GND 2.54113f **FLOATING
C1656 comp[51] GND 7.77545f
C1657 NAND3_12/a_n593_982# GND 3.4878f **FLOATING
C1658 wl[50] GND 2.74229f
C1659 NAND3_12/m1_n3706_n1374# GND 1.84123f **FLOATING
C1660 NAND3_12/a_2506_982# GND 3.7281f **FLOATING
C1661 NAND3_12/m1_n2243_n1314# GND 2.54113f **FLOATING
C1662 comp[61] GND 8.39238f
C1663 NAND3_2/a_n593_982# GND 3.4878f **FLOATING
C1664 wl[60] GND 2.74229f
C1665 NAND3_2/m1_n3706_n1374# GND 1.84123f **FLOATING
C1666 NAND3_2/a_2506_982# GND 3.7281f **FLOATING
C1667 NAND3_2/m1_n2243_n1314# GND 2.54113f **FLOATING
C1668 comp[8] GND 8.50855f
C1669 NAND3_55/a_n593_982# GND 3.4878f **FLOATING
C1670 wl[7] GND 2.74228f
C1671 NAND3_55/m1_n3706_n1374# GND 1.84123f **FLOATING
C1672 NAND3_55/a_2506_982# GND 3.7281f **FLOATING
C1673 NAND3_55/m1_n2243_n1314# GND 2.54113f **FLOATING
C1674 comp[19] GND 8.16541f
C1675 NAND3_44/a_n593_982# GND 3.4878f **FLOATING
C1676 wl[18] GND 2.74229f
C1677 NAND3_44/m1_n3706_n1374# GND 1.84123f **FLOATING
C1678 NAND3_44/a_2506_982# GND 3.7281f **FLOATING
C1679 NAND3_44/m1_n2243_n1314# GND 2.54113f **FLOATING
C1680 comp[30] GND 7.50376f
C1681 NAND3_33/a_n593_982# GND 3.4878f **FLOATING
C1682 wl[29] GND 2.74228f
C1683 NAND3_33/m1_n3706_n1374# GND 1.84123f **FLOATING
C1684 NAND3_33/a_2506_982# GND 3.7281f **FLOATING
C1685 NAND3_33/m1_n2243_n1314# GND 2.54113f **FLOATING
C1686 comp[41] GND 8.83671f
C1687 NAND3_22/a_n593_982# GND 3.4878f **FLOATING
C1688 wl[40] GND 2.74229f
C1689 NAND3_22/m1_n3706_n1374# GND 1.84123f **FLOATING
C1690 NAND3_22/a_2506_982# GND 3.7281f **FLOATING
C1691 NAND3_22/m1_n2243_n1314# GND 2.54113f **FLOATING
C1692 comp[52] GND 7.78651f
C1693 NAND3_11/a_n593_982# GND 3.4878f **FLOATING
C1694 wl[51] GND 2.74228f
C1695 NAND3_11/m1_n3706_n1374# GND 1.84123f **FLOATING
C1696 NAND3_11/a_2506_982# GND 3.7281f **FLOATING
C1697 NAND3_11/m1_n2243_n1314# GND 2.54113f **FLOATING
C1698 comp[62] GND 6.14001f
C1699 NAND3_1/a_n593_982# GND 3.4878f **FLOATING
C1700 wl[61] GND 2.74228f
C1701 NAND3_1/m1_n3706_n1374# GND 1.84123f **FLOATING
C1702 NAND3_1/a_2506_982# GND 3.7281f **FLOATING
C1703 NAND3_1/m1_n2243_n1314# GND 2.54113f **FLOATING
C1704 comp[9] GND 7.77545f
C1705 NAND3_54/a_n593_982# GND 3.4878f **FLOATING
C1706 wl[8] GND 2.74229f
C1707 NAND3_54/m1_n3706_n1374# GND 1.84123f **FLOATING
C1708 NAND3_54/a_2506_982# GND 3.7281f **FLOATING
C1709 NAND3_54/m1_n2243_n1314# GND 2.54113f **FLOATING
C1710 comp[20] GND 8.50855f
C1711 NAND3_43/a_n593_982# GND 3.4878f **FLOATING
C1712 wl[19] GND 2.74228f
C1713 NAND3_43/m1_n3706_n1374# GND 1.84123f **FLOATING
C1714 NAND3_43/a_2506_982# GND 3.7281f **FLOATING
C1715 NAND3_43/m1_n2243_n1314# GND 2.54113f **FLOATING
C1716 comp[31] GND 8.16541f
C1717 NAND3_32/a_n593_982# GND 3.4878f **FLOATING
C1718 wl[30] GND 2.74229f
C1719 NAND3_32/m1_n3706_n1374# GND 1.84123f **FLOATING
C1720 NAND3_32/a_2506_982# GND 3.7281f **FLOATING
C1721 NAND3_32/m1_n2243_n1314# GND 2.54113f **FLOATING
C1722 comp[42] GND 7.50376f
C1723 NAND3_21/a_n593_982# GND 3.4878f **FLOATING
C1724 wl[41] GND 2.74228f
C1725 NAND3_21/m1_n3706_n1374# GND 1.84123f **FLOATING
C1726 NAND3_21/a_2506_982# GND 3.7281f **FLOATING
C1727 NAND3_21/m1_n2243_n1314# GND 2.54113f **FLOATING
C1728 comp[53] GND 8.83671f
C1729 NAND3_10/a_n593_982# GND 3.4878f **FLOATING
C1730 wl[52] GND 2.74228f
C1731 NAND3_10/m1_n3706_n1374# GND 1.84123f **FLOATING
C1732 NAND3_10/a_2506_982# GND 3.7281f **FLOATING
C1733 NAND3_10/m1_n2243_n1314# GND 2.54113f **FLOATING
C1734 NAND3_0/a_n593_982# GND 4.88994f **FLOATING
C1735 wl[62] GND 2.74796f
C1736 NAND3_0/m1_n3706_n1374# GND 2.05391f **FLOATING
C1737 NAND3_0/a_2506_982# GND 4.03766f **FLOATING
C1738 NAND3_0/m1_n2243_n1314# GND 2.7505f **FLOATING
C1739 comp[10] GND 7.78651f
C1740 NAND3_53/a_n593_982# GND 3.4878f **FLOATING
C1741 wl[9] GND 2.74229f
C1742 NAND3_53/m1_n3706_n1374# GND 1.84123f **FLOATING
C1743 NAND3_53/a_2506_982# GND 3.7281f **FLOATING
C1744 NAND3_53/m1_n2243_n1314# GND 2.54113f **FLOATING
C1745 comp[21] GND 7.77545f
C1746 NAND3_42/a_n593_982# GND 3.4878f **FLOATING
C1747 wl[20] GND 2.74229f
C1748 NAND3_42/m1_n3706_n1374# GND 1.84123f **FLOATING
C1749 NAND3_42/a_2506_982# GND 3.7281f **FLOATING
C1750 NAND3_42/m1_n2243_n1314# GND 2.54113f **FLOATING
C1751 comp[32] GND 8.50855f
C1752 NAND3_31/a_n593_982# GND 3.4878f **FLOATING
C1753 wl[31] GND 2.74228f
C1754 NAND3_31/m1_n3706_n1374# GND 1.84123f **FLOATING
C1755 NAND3_31/a_2506_982# GND 3.7281f **FLOATING
C1756 NAND3_31/m1_n2243_n1314# GND 2.54113f **FLOATING
C1757 comp[43] GND 8.16541f
C1758 NAND3_20/a_n593_982# GND 3.4878f **FLOATING
C1759 wl[42] GND 2.74229f
C1760 NAND3_20/m1_n3706_n1374# GND 1.84123f **FLOATING
C1761 NAND3_20/a_2506_982# GND 3.7281f **FLOATING
C1762 NAND3_20/m1_n2243_n1314# GND 2.54113f **FLOATING
C1763 comp[11] GND 8.83904f
C1764 NAND3_52/a_n593_982# GND 3.4878f **FLOATING
C1765 wl[10] GND 2.74229f
C1766 NAND3_52/m1_n3706_n1374# GND 1.84123f **FLOATING
C1767 NAND3_52/a_2506_982# GND 3.7281f **FLOATING
C1768 NAND3_52/m1_n2243_n1314# GND 2.54113f **FLOATING
C1769 comp[22] GND 7.78651f
C1770 NAND3_41/a_n593_982# GND 3.4878f **FLOATING
C1771 wl[21] GND 2.74228f
C1772 NAND3_41/m1_n3706_n1374# GND 1.84123f **FLOATING
C1773 NAND3_41/a_2506_982# GND 3.7281f **FLOATING
C1774 NAND3_41/m1_n2243_n1314# GND 2.54113f **FLOATING
C1775 comp[33] GND 7.77545f
C1776 NAND3_30/a_n593_982# GND 3.4878f **FLOATING
C1777 wl[32] GND 2.74229f
C1778 NAND3_30/m1_n3706_n1374# GND 1.84123f **FLOATING
C1779 NAND3_30/a_2506_982# GND 3.7281f **FLOATING
C1780 NAND3_30/m1_n2243_n1314# GND 2.54113f **FLOATING
C1781 comp[1] GND 8.33221f
C1782 m1_n4168_2156# GND 4.18878f **FLOATING
C1783 NAND3_62/a_n593_982# GND 3.4847f **FLOATING
C1784 wl[0] GND 2.7438f
C1785 NAND3_62/m1_n3706_n1374# GND 1.81547f **FLOATING
C1786 NAND3_62/a_2506_982# GND 3.7262f **FLOATING
C1787 NAND3_62/m1_n2243_n1314# GND 2.51624f **FLOATING
C1788 VDD GND 1.64565p
C1789 comp[12] GND 7.50608f
C1790 NAND3_51/a_n593_982# GND 3.4878f **FLOATING
C1791 wl[11] GND 2.74228f
C1792 NAND3_51/m1_n3706_n1374# GND 1.84123f **FLOATING
C1793 NAND3_51/a_2506_982# GND 3.7281f **FLOATING
C1794 NAND3_51/m1_n2243_n1314# GND 2.54113f **FLOATING
C1795 comp[23] GND 8.83671f
C1796 NAND3_40/a_n593_982# GND 3.4878f **FLOATING
C1797 wl[22] GND 2.74229f
C1798 NAND3_40/m1_n3706_n1374# GND 1.84123f **FLOATING
C1799 NAND3_40/a_2506_982# GND 3.7281f **FLOATING
C1800 NAND3_40/m1_n2243_n1314# GND 2.54113f **FLOATING
C1801 comp[2] GND 8.50855f
C1802 NAND3_61/a_n593_982# GND 3.4878f **FLOATING
C1803 wl[1] GND 2.74228f
C1804 NAND3_61/m1_n3706_n1374# GND 1.84123f **FLOATING
C1805 NAND3_61/a_2506_982# GND 3.7281f **FLOATING
C1806 NAND3_61/m1_n2243_n1314# GND 2.54113f **FLOATING
C1807 comp[13] GND 8.16541f
C1808 NAND3_50/a_n593_982# GND 3.4878f **FLOATING
C1809 wl[12] GND 2.74229f
C1810 NAND3_50/m1_n3706_n1374# GND 1.84123f **FLOATING
C1811 NAND3_50/a_2506_982# GND 3.7281f **FLOATING
C1812 NAND3_50/m1_n2243_n1314# GND 2.54113f **FLOATING
C1813 comp[3] GND 7.77545f
C1814 NAND3_60/a_n593_982# GND 3.4878f **FLOATING
C1815 wl[2] GND 2.74229f
C1816 NAND3_60/m1_n3706_n1374# GND 1.84123f **FLOATING
C1817 NAND3_60/a_2506_982# GND 3.7281f **FLOATING
C1818 NAND3_60/m1_n2243_n1314# GND 2.54113f **FLOATING
