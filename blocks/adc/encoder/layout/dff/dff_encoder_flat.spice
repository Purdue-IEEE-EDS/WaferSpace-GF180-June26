* SPICE3 file created from dff_encoder_flat.ext - technology: gf180mcuD

.option scale=5n

X0 a_1717_516# a_1020_1572# a_1501_516# GND nfet_03v3 ad=9.12n pd=0.396m as=5.928n ps=0.236m w=72 l=56
X1 a_2331_1572# a_1717_516# VDD VDD pfet_03v3 ad=22.88n pd=0.612m as=14.784n ps=0.344m w=176 l=56
X2 VDD RST a_1717_516# VDD pfet_03v3 ad=14.784n pd=0.344m as=22.88n ps=0.612m w=176 l=56
X3 a_1020_1572# CLK a_796_1572# VDD pfet_03v3 ad=22.88n pd=0.612m as=14.784n ps=0.344m w=176 l=56
X4 a_2332_516# a_1717_516# GND GND nfet_03v3 ad=5.928n pd=0.236m as=9.12n ps=0.396m w=72 l=56
X5 GND D a_1020_1572# GND nfet_03v3 ad=5.928n pd=0.236m as=9.12n ps=0.396m w=72 l=56
X6 a_796_1572# D VDD VDD pfet_03v3 ad=14.784n pd=0.344m as=22.88n ps=0.612m w=176 l=56
X7 a_2331_1572# CLK a_2332_516# GND nfet_03v3 ad=9.12n pd=0.396m as=5.928n ps=0.236m w=72 l=56
X8 a_1501_516# CLK GND GND nfet_03v3 ad=5.928n pd=0.236m as=5.928n ps=0.236m w=72 l=56
X9 a_1717_516# a_1020_1572# a_1500_1572# VDD pfet_03v3 ad=22.88n pd=0.612m as=14.784n ps=0.344m w=176 l=56
X10 Q a_2331_1572# VDD VDD pfet_03v3 ad=45.76n pd=0.964m as=45.76n ps=0.964m w=352 l=56
X11 Q a_2331_1572# GND GND nfet_03v3 ad=21.472n pd=0.596m as=21.472n ps=0.596m w=176 l=56
X12 a_1500_1572# CLK VDD VDD pfet_03v3 ad=14.784n pd=0.344m as=22.88n ps=0.612m w=176 l=56
C0 a_1020_1572# a_1717_516# 0.26777f
C1 CLK RST 0.15126f
C2 a_1500_1572# a_1717_516# 0.02732f
C3 RST VDD 0.19558f
C4 a_796_1572# VDD 0.07689f
C5 CLK a_1717_516# 0.27206f
C6 a_1500_1572# a_1020_1572# 0.01824f
C7 D RST 0.2565f
C8 VDD a_1717_516# 0.41817f
C9 a_1501_516# RST 0.01313f
C10 a_2331_1572# a_2332_516# 0.03263f
C11 CLK a_1020_1572# 0.83074f
C12 a_1020_1572# VDD 0.35478f
C13 a_1501_516# a_1717_516# 0.02941f
C14 Q VDD 0.45219f
C15 a_1500_1572# VDD 0.07618f
C16 a_2331_1572# a_1717_516# 0.11454f
C17 D a_1020_1572# 0.15646f
C18 CLK VDD 0.40573f
C19 RST a_1717_516# 0.55983f
C20 Q a_2331_1572# 0.12418f
C21 D CLK 0.26838f
C22 D VDD 0.18386f
C23 RST a_1020_1572# 0.28962f
C24 CLK a_2331_1572# 0.12355f
C25 a_796_1572# a_1020_1572# 0.02988f
C26 a_2331_1572# VDD 0.5934f
C27 Q GND 0.58565f
C28 RST GND 0.5624f
C29 CLK GND 1.15005f
C30 D GND 0.70721f
C31 VDD GND 4.91413f
C32 a_2332_516# GND 0.12668f **FLOATING
C33 a_1501_516# GND 0.12166f **FLOATING
C34 a_2331_1572# GND 0.77469f **FLOATING
C35 a_1717_516# GND 0.74549f **FLOATING
C36 a_1020_1572# GND 0.79444f **FLOATING
