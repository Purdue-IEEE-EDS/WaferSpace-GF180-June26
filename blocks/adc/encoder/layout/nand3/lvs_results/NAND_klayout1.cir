* Extracted by KLayout with GF180MCU LVS runset on : 30/05/2026 22:16

.SUBCKT NAND3
M$1 VDD \$7 OUT VDD pfet_03v3 L=0.28U W=16.5U AS=5.577P AD=5.577P PS=23.18U
+ PD=23.18U
M$6 VDD A \$7 VDD pfet_03v3 L=0.28U W=16.5U AS=5.577P AD=5.577P PS=23.18U
+ PD=23.18U
M$11 VDD B \$7 VDD pfet_03v3 L=0.28U W=16.5U AS=5.577P AD=5.577P PS=23.18U
+ PD=23.18U
M$16 VDD \$10 \$7 VDD pfet_03v3 L=0.28U W=16.5U AS=5.577P AD=5.577P PS=23.18U
+ PD=23.18U
M$21 VDD C \$10 VDD pfet_03v3 L=0.28U W=16.5U AS=5.577P AD=5.577P PS=23.18U
+ PD=23.18U
M$26 OUT \$7 GND GND nfet_03v3 L=0.28U W=10.16U AS=3.5306P AD=3.5306P PS=15.48U
+ PD=15.48U
M$30 \$2 B \$3 GND nfet_03v3 L=0.28U W=10.16U AS=3.5306P AD=3.5306P PS=15.48U
+ PD=15.48U
M$34 \$10 C GND GND nfet_03v3 L=0.28U W=10.16U AS=3.5306P AD=3.5306P PS=15.48U
+ PD=15.48U
M$38 \$3 \$10 GND GND nfet_03v3 L=0.28U W=10.16U AS=3.5306P AD=3.5306P
+ PS=15.48U PD=15.48U
M$42 \$7 A \$2 GND nfet_03v3 L=0.28U W=10.16U AS=3.5306P AD=3.5306P PS=15.48U
+ PD=15.48U
.ENDS NAND3
