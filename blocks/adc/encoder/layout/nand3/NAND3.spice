* NGSPICE file created from NAND3.ext - technology: gf180mcuD

.subckt pfet a_734_0# a_28_n136# a_254_0# a_188_n136# a_348_n136# a_414_0# a_n92_0#
+ a_94_0# a_574_0# a_508_n136# a_668_n136# w_n230_n138# VSUBS
X0 a_734_0# a_668_n136# a_574_0# w_n230_n138# pfet_03v3 ad=2.145p pd=7.9u as=0.858p ps=3.82u w=3.3u l=0.28u
X1 a_254_0# a_188_n136# a_94_0# w_n230_n138# pfet_03v3 ad=0.858p pd=3.82u as=0.858p ps=3.82u w=3.3u l=0.28u
X2 a_574_0# a_508_n136# a_414_0# w_n230_n138# pfet_03v3 ad=0.858p pd=3.82u as=0.858p ps=3.82u w=3.3u l=0.28u
X3 a_94_0# a_28_n136# a_n92_0# w_n230_n138# pfet_03v3 ad=0.858p pd=3.82u as=2.145p ps=7.9u w=3.3u l=0.28u
X4 a_414_0# a_348_n136# a_254_0# w_n230_n138# pfet_03v3 ad=0.858p pd=3.82u as=0.858p ps=3.82u w=3.3u l=0.28u
C0 a_28_n136# a_188_n136# 0.06717f
C1 a_734_0# w_n230_n138# 0.4196f
C2 a_28_n136# w_n230_n138# 0.12042f
C3 a_188_n136# a_348_n136# 0.06717f
C4 a_348_n136# w_n230_n138# 0.10304f
C5 a_734_0# a_668_n136# 0.02318f
C6 a_508_n136# w_n230_n138# 0.10304f
C7 a_n92_0# w_n230_n138# 0.03499f
C8 a_254_0# a_188_n136# 0.02517f
C9 a_94_0# a_28_n136# 0.02517f
C10 a_668_n136# a_508_n136# 0.06717f
C11 a_414_0# a_348_n136# 0.02517f
C12 a_94_0# a_n92_0# 0.23758f
C13 a_414_0# a_508_n136# 0.02517f
C14 a_94_0# a_254_0# 0.32736f
C15 a_668_n136# a_574_0# 0.02517f
C16 a_414_0# a_254_0# 0.32736f
C17 a_28_n136# a_n92_0# 0.02318f
C18 a_188_n136# w_n230_n138# 0.10304f
C19 a_414_0# a_574_0# 0.32736f
C20 a_734_0# a_574_0# 0.23758f
C21 a_348_n136# a_508_n136# 0.06717f
C22 a_254_0# a_348_n136# 0.02517f
C23 a_668_n136# w_n230_n138# 0.12611f
C24 a_94_0# a_188_n136# 0.02517f
C25 a_574_0# a_508_n136# 0.02517f
C26 a_734_0# VSUBS 0.02093f
C27 a_574_0# VSUBS 0.02093f
C28 a_414_0# VSUBS 0.02093f
C29 a_254_0# VSUBS 0.02093f
C30 a_94_0# VSUBS 0.02093f
C31 a_n92_0# VSUBS 0.10673f
C32 a_668_n136# VSUBS 0.0592f
C33 a_508_n136# VSUBS 0.04564f
C34 a_348_n136# VSUBS 0.04564f
C35 a_188_n136# VSUBS 0.04564f
C36 a_28_n136# VSUBS 0.06489f
C37 w_n230_n138# VSUBS 3.95749f
.ends

.subckt nfet$1 a_350_568# a_254_0# a_414_0# a_510_568# a_190_568# a_n84_0# a_30_568#
+ a_94_0# a_574_0# a_696_0#
X0 a_254_0# a_190_568# a_94_0# a_696_0# nfet_03v3 ad=0.6604p pd=3.06u as=0.6604p ps=3.06u w=2.54u l=0.28u
X1 a_574_0# a_510_568# a_414_0# a_696_0# nfet_03v3 ad=1.5494p pd=6.3u as=0.6604p ps=3.06u w=2.54u l=0.28u
X2 a_94_0# a_30_568# a_n84_0# a_696_0# nfet_03v3 ad=0.6604p pd=3.06u as=1.5494p ps=6.3u w=2.54u l=0.28u
X3 a_414_0# a_350_568# a_254_0# a_696_0# nfet_03v3 ad=0.6604p pd=3.06u as=0.6604p ps=3.06u w=2.54u l=0.28u
C0 a_414_0# a_254_0# 0.2134f
C1 a_350_568# a_414_0# 0.01674f
C2 a_94_0# a_190_568# 0.01674f
C3 a_510_568# a_574_0# 0.01563f
C4 a_190_568# a_254_0# 0.01674f
C5 a_190_568# a_30_568# 0.0661f
C6 a_190_568# a_350_568# 0.0661f
C7 a_94_0# a_254_0# 0.2134f
C8 a_510_568# a_350_568# 0.0661f
C9 a_94_0# a_30_568# 0.01674f
C10 a_94_0# a_n84_0# 0.16004f
C11 a_510_568# a_414_0# 0.01674f
C12 a_574_0# a_414_0# 0.16004f
C13 a_350_568# a_254_0# 0.01674f
C14 a_n84_0# a_30_568# 0.01563f
C15 a_574_0# a_696_0# 0.31292f
C16 a_414_0# a_696_0# 0.02648f
C17 a_254_0# a_696_0# 0.02648f
C18 a_94_0# a_696_0# 0.02648f
C19 a_n84_0# a_696_0# 0.10124f
C20 a_510_568# a_696_0# 0.18161f
C21 a_350_568# a_696_0# 0.14578f
C22 a_190_568# a_696_0# 0.14578f
C23 a_30_568# a_696_0# 0.18161f
.ends

.subckt NAND3 B A GND OUT C VDD
Xpfet_0 VDD A a_n4238_2071# A A VDD a_n4238_2071# VDD a_n4238_2071# A A VDD GND pfet
Xpfet_1 VDD B a_n4238_2071# B B VDD a_n4238_2071# VDD a_n4238_2071# B B VDD GND pfet
Xpfet_2 VDD a_n7290_3558# a_n4238_2071# a_n7290_3558# a_n7290_3558# VDD a_n4238_2071#
+ VDD a_n4238_2071# a_n7290_3558# a_n7290_3558# VDD GND pfet
Xpfet_4 VDD a_n4238_2071# OUT a_n4238_2071# a_n4238_2071# VDD OUT VDD OUT a_n4238_2071#
+ a_n4238_2071# VDD GND pfet
Xpfet_3 VDD C a_n7290_3558# C C VDD a_n7290_3558# VDD a_n7290_3558# C C VDD GND pfet
Xnfet$1_0 A m1_n10403_1202# a_n4238_2071# A A m1_n10403_1202# A a_n4238_2071# m1_n10403_1202#
+ GND nfet$1
Xnfet$1_1 B m1_n8940_1262# m1_n10403_1202# B B m1_n8940_1262# B m1_n10403_1202# m1_n8940_1262#
+ GND nfet$1
Xnfet$1_2 a_n7290_3558# GND m1_n8940_1262# a_n7290_3558# a_n7290_3558# GND a_n7290_3558#
+ m1_n8940_1262# GND GND nfet$1
Xnfet$1_3 C GND a_n7290_3558# C C GND C a_n7290_3558# GND GND nfet$1
Xnfet$1_4 a_n4238_2071# GND OUT a_n4238_2071# a_n4238_2071# GND a_n4238_2071# OUT
+ GND GND nfet$1
C0 C a_n4238_2071# 0.30956f
C1 A C 0.08369f
C2 a_n4238_2071# OUT 0.91017f
C3 a_n7290_3558# B 0.05055f
C4 a_n7290_3558# m1_n8940_1262# 0.27291f
C5 VDD a_n4238_2071# 1.23794f
C6 B m1_n8940_1262# 0.09824f
C7 A VDD 0.28464f
C8 C a_n7290_3558# 1.2113f
C9 C B 0.37934f
C10 m1_n10403_1202# a_n4238_2071# 0.11831f
C11 C m1_n8940_1262# 0.20937f
C12 a_n7290_3558# OUT 0.05101f
C13 m1_n10403_1202# A 0.10806f
C14 a_n7290_3558# VDD 0.55922f
C15 B VDD 0.28679f
C16 A a_n4238_2071# 0.76907f
C17 m1_n10403_1202# B 0.25682f
C18 C VDD 0.27728f
C19 m1_n10403_1202# m1_n8940_1262# 0.18462f
C20 a_n7290_3558# a_n4238_2071# 0.99768f
C21 VDD OUT 0.31462f
C22 B a_n4238_2071# 0.67769f
C23 m1_n10403_1202# C 0.21268f
C24 A B 0.14855f
C25 C GND 1.15755f
C26 B GND 1.07122f
C27 A GND 0.84547f
C28 a_n7290_3558# GND 1.55572f
C29 OUT GND 0.92405f
C30 m1_n8940_1262# GND 1.27576f
C31 m1_n10403_1202# GND 1.32186f
C32 a_n4238_2071# GND 2.24764f
C33 VDD GND 5.15652f
.ends
