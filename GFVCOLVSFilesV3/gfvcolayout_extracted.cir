* Extracted by KLayout with GF180MCU LVS runset on : 13/07/2026 00:34

* cell gfvcolayout
* pin SUB
.SUBCKT gfvcolayout SUB
* device instance $1 r0 *1 167.425,-0.205 cap_mim_2f0fF
C$1 SUB \$16 5e-14 cap_mim_2f0fF A=25P P=20U
* device instance $2 r0 *1 167.42,8.895 cap_mim_2f0fF
C$2 \$18 \$16 5e-14 cap_mim_2f0fF A=25P P=20U
* device instance $3 r0 *1 362.725,-0.205 cap_mim_2f0fF
C$3 SUB \$20 5e-14 cap_mim_2f0fF A=25P P=20U
* device instance $4 r0 *1 362.73,8.895 cap_mim_2f0fF
C$4 \$18 \$20 5e-14 cap_mim_2f0fF A=25P P=20U
* device instance $5 m0 *1 348.155,57.22 pfet_03v3
M$5 \$18 \$18 \$30 \$30 pfet_03v3 L=0.28U W=80U AS=23.92P AD=23.92P PS=99.96U
+ PD=99.96U
* device instance $25 m90 *1 356.64,-0.205 nfet_03v3
M$25 \$20 \$18 SUB SUB nfet_03v3 L=0.28U W=15U AS=5.65P AD=5.65P PS=22.26U
+ PD=22.26U
* device instance $28 m90 *1 357.19,8.395 nfet_03v3
M$28 \$18 \$18 \$20 SUB nfet_03v3 L=0.28U W=40U AS=11.8P AD=11.8P PS=49.9U
+ PD=49.9U
* device instance $38 r0 *1 173.51,-0.205 nfet_03v3
M$38 \$16 \$18 SUB SUB nfet_03v3 L=0.28U W=15U AS=5.65P AD=5.65P PS=22.26U
+ PD=22.26U
* device instance $41 r0 *1 172.96,8.395 nfet_03v3
M$41 \$18 \$18 \$16 SUB nfet_03v3 L=0.28U W=40U AS=11.8P AD=11.8P PS=49.9U
+ PD=49.9U
* device instance $51 r0 *1 165.895,49.802 nfet_03v3
M$51 \$30 \$18 \$28 SUB nfet_03v3 L=0.28U W=29.995U AS=9.29845P AD=9.29845P
+ PS=38.62U PD=38.62U
* device instance $58 m90 *1 364.255,49.802 nfet_03v3
M$58 \$30 \$18 \$29 SUB nfet_03v3 L=0.28U W=29.995U AS=9.29845P AD=9.29845P
+ PS=38.62U PD=38.62U
* device instance $65 r90 *1 265.075,-19.565 pplus_u
R$65 \$1 \$14 SUB 740 pplus_u L=20U W=5U
* device instance $66 r270 *1 168.545,31.89 pplus_u
R$66 \$28 SUB SUB 740 pplus_u L=20U W=5U
* device instance $67 r270 *1 361.605,31.89 pplus_u
R$67 \$29 SUB SUB 740 pplus_u L=20U W=5U
* device instance $68 m135 *1 288.025,32.33 nfet_03v3
M$68 \$18 \$14 \$18 \$18 nfet_03v3 L=20U W=176U AS=76.56P AD=76.56P PS=270.96U
+ PD=270.96U
.ENDS gfvcolayout
