* Extracted by KLayout with GF180MCU LVS runset on : 12/07/2026 21:14

* cell pplus_u_resistor
.SUBCKT pplus_u_resistor
* device instance $1 r0 *1 10,2.5 pplus_u
R$1 \$1 \$2 \$3 740 pplus_u L=20U W=5U
.ENDS pplus_u_resistor

* cell TOP
.SUBCKT TOP
.ENDS TOP
